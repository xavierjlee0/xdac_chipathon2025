** sch_path: /foss/designs/libs/core_analog/oscillator/triangle_osc.sch
.subckt triangle_osc vdd vho out vlo iref vss
*.PININFO iref:I vss:I vho:I vlo:I out:O vdd:I
M1 net1 iref vss vss nfet_03v3 L=1u W=4u nf=1 m=1
M8 net2 iref vss vss nfet_03v3 L=1u W=4u nf=1 m=1
M4 net1 net1 vdd vdd pfet_03v3 L=1u W=6u nf=1 m=1
M5 net3 net1 vdd vdd pfet_03v3 L=1u W=6u nf=1 m=1
M6 out nq net3 vdd pfet_03v3 L=1u W=6u nf=1 m=1
M7 out nq net2 vss nfet_03v3 L=1u W=4u nf=1 m=1
M2 iref iref vss vss nfet_03v3 L=1u W=4u nf=1 m=1
M10 net5 iref vss vss nfet_03v3 L=1u W=4u nf=1 m=1
M9 net4 net1 vdd vdd pfet_03v3 L=1u W=6u nf=1 m=1
xn_comp vdd vcompn vho vss out net4 Nmos_Comparator
xp_comp vdd vcompp out vss vlo net5 Pmos_Comparator
x1 vcompp q nq vcompn sr_latch
.ends

* expanding   symbol:  libs/core_analog/Comparator/Nmos_Comparator.sym # of pins=6
** sym_path: /foss/designs/libs/core_analog/Comparator/Nmos_Comparator.sym
** sch_path: /foss/designs/libs/core_analog/Comparator/Nmos_Comparator.sch
.subckt Nmos_Comparator vdd vout inp vss inn iref
*.PININFO vss:I vdd:I iref:I inn:I inp:I vout:O
M3 net1 net1 vss vss nfet_03v3 L=1u W=3.5u nf=1 m=1
M4 vout net1 vss vss nfet_03v3 L=1u W=3.5u nf=1 m=1
M5 net2 inn net3 vss nfet_03v3 L=1u W=4u nf=1 m=1
M6 net4 inp net3 vss nfet_03v3 L=1u W=4u nf=1 m=1
M7 net1 net2 vdd vdd pfet_03v3 L=0.5u W=16.5u nf=4 m=1
M9 net4 net4 vdd vdd pfet_03v3 L=0.5u W=10u nf=2 m=1
M11 net2 net2 vdd vdd pfet_03v3 L=0.5u W=10u nf=2 m=1
M12 vout net4 vdd vdd pfet_03v3 L=0.5u W=16.5u nf=4 m=1
M1 net4 net2 vdd vdd pfet_03v3 L=0.5u W=10u nf=2 m=1
M2 net2 net4 vdd vdd pfet_03v3 L=0.5u W=10u nf=2 m=1
M8 iref iref vss vss nfet_03v3 L=1u W=2.5u nf=1 m=1
M10 net3 iref vss vss nfet_03v3 L=1u W=5u nf=2 m=1
.ends

* expanding   symbol:  libs/core_analog/Comparator/Pmos_Comparator.sym # of pins=6
** sym_path: /foss/designs/libs/core_analog/Comparator/Pmos_Comparator.sym
** sch_path: /foss/designs/libs/core_analog/Comparator/Pmos_Comparator.sch
.subckt Pmos_Comparator vdd vout inp vss inn iref
*.PININFO vdd:I vss:I iref:I inn:I inp:I vout:O
M3 net1 net1 vdd vdd pfet_03v3 L=0.6u W=25u nf=5 m=1
M4 vout net1 vdd vdd pfet_03v3 L=0.6u W=25u nf=5 m=1
M5 net2 inn net3 vdd pfet_03v3 L=1u W=12u nf=4 m=1
M6 net4 inp net3 vdd pfet_03v3 L=1u W=12u nf=4 m=1
M7 net1 net2 vss vss nfet_03v3 L=1u W=5.5u nf=1 m=1
M8 net2 net4 vss vss nfet_03v3 L=1u W=5.5u nf=1 m=1
M9 net4 net4 vss vss nfet_03v3 L=1u W=5.5u nf=1 m=1
M10 net4 net2 vss vss nfet_03v3 L=1u W=5.5u nf=1 m=1
M11 net2 net2 vss vss nfet_03v3 L=1u W=5.5u nf=1 m=1
M12 vout net4 vss vss nfet_03v3 L=1u W=5.5u nf=1 m=1
M1 net3 iref vdd vdd pfet_03v3 L=1u W=14u nf=4 m=1
M2 iref iref vdd vdd pfet_03v3 L=1u W=7u nf=1 m=1
.ends

* expanding   symbol:  libs/core_analog/oscillator/sr_latch.sym # of pins=4
** sym_path: /foss/designs/libs/core_analog/oscillator/sr_latch.sym
** sch_path: /foss/designs/libs/core_analog/oscillator/sr_latch.sch
.subckt sr_latch NOTR Q NOTQ NOTS
*.PININFO NOTR:I NOTS:I Q:O NOTQ:O
x1 NOTR NOTQ Q VDDd VDDd VSSd VSSd gf180mcu_fd_sc_mcu9t5v0__nand2_2
x2 Q NOTS NOTQ VDDd VDDd VSSd VSSd gf180mcu_fd_sc_mcu9t5v0__nand2_2
.ends
