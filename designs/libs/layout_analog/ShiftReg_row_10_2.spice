** sch_path: /foss/designs/libs/core_swmatrix/ShiftReg_row_10_2.sch
.subckt ShiftReg_row_10_2 Q[1] Q[2] Q[3] Q[4] Q[5] Q[6] Q[7] Q[8] Q[9] Q[10] Q[11] Q[12] Q[13] Q[14] Q[15] Q[16] D_in PHI_1 PHI_2
+ I[1] I[2] I[3] I[4] I[5] I[6] I[7] I[8] I[9] I[10] I[11] I[12] I[13] I[14] I[15] I[16] EN VSSd VDDd
*.PININFO PHI_1:I PHI_2:I D_in:I Q[1:16]:O EN:I I[1:16]:O VSSd:I VDDd:I
xFF[1] D_in Q[1] PHI_1 PHI_2 EN I[1] VSSd VDDd DFF_2phase_1
xFF[2] Q[1] Q[2] PHI_1 PHI_2 EN I[2] VSSd VDDd DFF_2phase_1
xFF[3] Q[2] Q[3] PHI_1 PHI_2 EN I[3] VSSd VDDd DFF_2phase_1
xFF[4] Q[3] Q[4] PHI_1 PHI_2 EN I[4] VSSd VDDd DFF_2phase_1
xFF[5] Q[4] Q[5] PHI_1 PHI_2 EN I[5] VSSd VDDd DFF_2phase_1
xFF[6] Q[5] Q[6] PHI_1 PHI_2 EN I[6] VSSd VDDd DFF_2phase_1
xFF[7] Q[6] Q[7] PHI_1 PHI_2 EN I[7] VSSd VDDd DFF_2phase_1
xFF[8] Q[7] Q[8] PHI_1 PHI_2 EN I[8] VSSd VDDd DFF_2phase_1
xFF[9] Q[8] Q[9] PHI_1 PHI_2 EN I[9] VSSd VDDd DFF_2phase_1
xFF[10] Q[9] Q[10] PHI_1 PHI_2 EN I[10] VSSd VDDd DFF_2phase_1
xFF[11] Q[10] Q[11] PHI_1 PHI_2 EN I[11] VSSd VDDd DFF_2phase_1
xFF[12] Q[11] Q[12] PHI_1 PHI_2 EN I[12] VSSd VDDd DFF_2phase_1
xFF[13] Q[12] Q[13] PHI_1 PHI_2 EN I[13] VSSd VDDd DFF_2phase_1
xFF[14] Q[13] Q[14] PHI_1 PHI_2 EN I[14] VSSd VDDd DFF_2phase_1
xFF[15] Q[14] Q[15] PHI_1 PHI_2 EN I[15] VSSd VDDd DFF_2phase_1
xFF[16] Q[15] Q[16] PHI_1 PHI_2 EN I[16] VSSd VDDd DFF_2phase_1
.ends

* expanding   symbol:  libs/core_swmatrix/DFF_2phase_1.sym # of pins=8
** sym_path: /foss/designs/libs/core_swmatrix/DFF_2phase_1.sym
** sch_path: /foss/designs/libs/core_swmatrix/DFF_2phase_1.sch
.subckt DFF_2phase_1 D Q PHI_1 PHI_2 EN I VSSd VDDd
*.PININFO D:I PHI_1:I PHI_2:I Q:O EN:I I:O VSSd:I VDDd:I
xmain D PHI_1 out_m VDDd VDDd VSSd VSSd gf180mcu_fd_sc_mcu9t5v0__latq_1
xsecondary out_m PHI_2 Q VDDd VDDd VSSd VSSd gf180mcu_fd_sc_mcu9t5v0__latq_1
x2 EN Q net1 VDDd VDDd VSSd VSSd gf180mcu_fd_sc_mcu9t5v0__nand2_1
x3 net1 I VDDd VDDd VSSd VSSd gf180mcu_fd_sc_mcu9t5v0__inv_1
* noconn VSSd
* noconn VDDd
.ends
