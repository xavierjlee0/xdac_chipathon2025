* NGSPICE file created from Pmos_Comparator.ext - technology: gf180mcuD

.subckt pfet a_342_n60# a_238_0# a_542_0# a_38_n60# a_n92_0# w_n230_n138# VSUBS
X0 a_542_0# a_342_n60# a_238_0# w_n230_n138# pfet_03v3 ad=2.275p pd=8.3u as=0.91p ps=4.02u w=3.5u l=1u
X1 a_238_0# a_38_n60# a_n92_0# w_n230_n138# pfet_03v3 ad=0.91p pd=4.02u as=2.275p ps=8.3u w=3.5u l=1u
C0 a_n92_0# w_n230_n138# 0.03476f
C1 a_342_n60# a_542_0# 0.05833f
C2 a_238_0# a_542_0# 0.10459f
C3 a_342_n60# a_238_0# 0.06632f
C4 a_542_0# w_n230_n138# 0.41937f
C5 a_342_n60# w_n230_n138# 0.21243f
C6 a_38_n60# a_n92_0# 0.05833f
C7 a_238_0# w_n230_n138# 0.00675f
C8 a_342_n60# a_38_n60# 0.04083f
C9 a_38_n60# a_238_0# 0.06632f
C10 a_38_n60# w_n230_n138# 0.20722f
C11 a_238_0# a_n92_0# 0.10459f
C12 a_542_0# VSUBS 0.02006f
C13 a_238_0# VSUBS 0.02006f
C14 a_n92_0# VSUBS 0.10586f
C15 a_342_n60# VSUBS 0.2103f
C16 a_38_n60# VSUBS 0.21551f
C17 w_n230_n138# VSUBS 3.55871f
.ends

.subckt pfet$2 a_846_0# a_342_n60# a_238_0# a_950_n60# a_542_0# a_38_n60# a_n92_0#
+ a_1150_0# a_646_n60# w_n230_n138# VSUBS
X0 a_846_0# a_646_n60# a_542_0# w_n230_n138# pfet_03v3 ad=0.78p pd=3.52u as=0.78p ps=3.52u w=3u l=1u
X1 a_1150_0# a_950_n60# a_846_0# w_n230_n138# pfet_03v3 ad=1.95p pd=7.3u as=0.78p ps=3.52u w=3u l=1u
X2 a_542_0# a_342_n60# a_238_0# w_n230_n138# pfet_03v3 ad=0.78p pd=3.52u as=0.78p ps=3.52u w=3u l=1u
X3 a_238_0# a_38_n60# a_n92_0# w_n230_n138# pfet_03v3 ad=0.78p pd=3.52u as=1.95p ps=7.3u w=3u l=1u
C0 a_646_n60# w_n230_n138# 0.19193f
C1 a_542_0# a_342_n60# 0.05478f
C2 a_238_0# a_38_n60# 0.05478f
C3 a_950_n60# a_1150_0# 0.04818f
C4 a_846_0# a_1150_0# 0.08639f
C5 a_542_0# a_846_0# 0.09387f
C6 w_n230_n138# a_1150_0# 0.34753f
C7 a_950_n60# a_846_0# 0.05478f
C8 a_n92_0# w_n230_n138# 0.02987f
C9 a_542_0# w_n230_n138# 0.00673f
C10 a_342_n60# w_n230_n138# 0.19193f
C11 a_950_n60# w_n230_n138# 0.2125f
C12 a_846_0# w_n230_n138# 0.00673f
C13 a_238_0# a_n92_0# 0.08639f
C14 a_38_n60# a_n92_0# 0.04818f
C15 a_542_0# a_238_0# 0.09387f
C16 a_342_n60# a_238_0# 0.05478f
C17 a_342_n60# a_38_n60# 0.04083f
C18 a_542_0# a_646_n60# 0.05478f
C19 a_342_n60# a_646_n60# 0.04083f
C20 a_238_0# w_n230_n138# 0.00673f
C21 a_38_n60# w_n230_n138# 0.20729f
C22 a_950_n60# a_646_n60# 0.04083f
C23 a_646_n60# a_846_0# 0.05478f
C24 a_1150_0# VSUBS 0.02002f
C25 a_846_0# VSUBS 0.02002f
C26 a_542_0# VSUBS 0.02002f
C27 a_238_0# VSUBS 0.02002f
C28 a_n92_0# VSUBS 0.09089f
C29 a_950_n60# VSUBS 0.21069f
C30 a_646_n60# VSUBS 0.19795f
C31 a_342_n60# VSUBS 0.19795f
C32 a_38_n60# VSUBS 0.2159f
C33 w_n230_n138# VSUBS 4.78859f
.ends

.subckt nfet a_360_0# a_238_0# a_38_n60# a_n84_0#
X0 a_238_0# a_38_n60# a_n84_0# a_360_0# nfet_03v3 ad=3.355p pd=12.22u as=3.355p ps=12.22u w=5.5u l=1u
C0 a_38_n60# a_n84_0# 0.10065f
C1 a_238_0# a_n84_0# 0.16839f
C2 a_238_0# a_38_n60# 0.10065f
C3 a_238_0# a_360_0# 0.77236f
C4 a_n84_0# a_360_0# 0.22154f
C5 a_38_n60# a_360_0# 0.45084f
.ends

.subckt pfet$5 a_1054_0# a_382_0# a_606_0# a_486_n60# a_262_n60# a_158_0# a_38_n60#
+ a_n92_0# a_934_n60# a_710_n60# a_830_0# w_n230_n138# VSUBS
X0 a_830_0# a_710_n60# a_606_0# w_n230_n138# pfet_03v3 ad=1.3p pd=5.52u as=1.3p ps=5.52u w=5u l=0.6u
X1 a_1054_0# a_934_n60# a_830_0# w_n230_n138# pfet_03v3 ad=3.25p pd=11.3u as=1.3p ps=5.52u w=5u l=0.6u
X2 a_382_0# a_262_n60# a_158_0# w_n230_n138# pfet_03v3 ad=1.3p pd=5.52u as=1.3p ps=5.52u w=5u l=0.6u
X3 a_606_0# a_486_n60# a_382_0# w_n230_n138# pfet_03v3 ad=1.3p pd=5.52u as=1.3p ps=5.52u w=5u l=0.6u
X4 a_158_0# a_38_n60# a_n92_0# w_n230_n138# pfet_03v3 ad=1.3p pd=5.52u as=3.25p ps=11.3u w=5u l=0.6u
C0 a_1054_0# a_934_n60# 0.0629f
C1 a_n92_0# a_38_n60# 0.0629f
C2 a_262_n60# a_158_0# 0.07048f
C3 a_830_0# a_606_0# 0.27074f
C4 w_n230_n138# a_934_n60# 0.1603f
C5 a_710_n60# a_934_n60# 0.04716f
C6 w_n230_n138# a_38_n60# 0.15488f
C7 a_486_n60# w_n230_n138# 0.13919f
C8 a_n92_0# w_n230_n138# 0.04942f
C9 a_1054_0# w_n230_n138# 0.63487f
C10 a_486_n60# a_710_n60# 0.04716f
C11 w_n230_n138# a_710_n60# 0.13919f
C12 a_486_n60# a_382_0# 0.07048f
C13 w_n230_n138# a_382_0# 0.00678f
C14 a_486_n60# a_606_0# 0.07048f
C15 w_n230_n138# a_606_0# 0.00678f
C16 a_710_n60# a_606_0# 0.07048f
C17 a_158_0# a_38_n60# 0.07048f
C18 a_262_n60# a_38_n60# 0.04716f
C19 a_n92_0# a_158_0# 0.23075f
C20 a_486_n60# a_262_n60# 0.04716f
C21 a_382_0# a_606_0# 0.27074f
C22 a_158_0# w_n230_n138# 0.00678f
C23 a_262_n60# w_n230_n138# 0.13919f
C24 a_830_0# a_934_n60# 0.07048f
C25 a_1054_0# a_830_0# 0.23075f
C26 a_158_0# a_382_0# 0.27074f
C27 a_262_n60# a_382_0# 0.07048f
C28 a_830_0# w_n230_n138# 0.00678f
C29 a_830_0# a_710_n60# 0.07048f
C30 a_1054_0# VSUBS 0.02019f
C31 a_830_0# VSUBS 0.02019f
C32 a_606_0# VSUBS 0.02019f
C33 a_382_0# VSUBS 0.02019f
C34 a_158_0# VSUBS 0.02019f
C35 a_n92_0# VSUBS 0.15079f
C36 a_934_n60# VSUBS 0.13822f
C37 a_710_n60# VSUBS 0.12508f
C38 a_486_n60# VSUBS 0.12508f
C39 a_262_n60# VSUBS 0.12508f
C40 a_38_n60# VSUBS 0.14363f
C41 w_n230_n138# VSUBS 6.62247f
.ends

.subckt pfet$3 a_846_0# a_342_n60# a_238_0# a_950_n60# a_542_0# a_38_n60# a_n92_0#
+ a_1150_0# a_646_n60# w_n230_n138# VSUBS
X0 a_846_0# a_646_n60# a_542_0# w_n230_n138# pfet_03v3 ad=0.91p pd=4.02u as=0.91p ps=4.02u w=3.5u l=1u
X1 a_1150_0# a_950_n60# a_846_0# w_n230_n138# pfet_03v3 ad=2.275p pd=8.3u as=0.91p ps=4.02u w=3.5u l=1u
X2 a_542_0# a_342_n60# a_238_0# w_n230_n138# pfet_03v3 ad=0.91p pd=4.02u as=0.91p ps=4.02u w=3.5u l=1u
X3 a_238_0# a_38_n60# a_n92_0# w_n230_n138# pfet_03v3 ad=0.91p pd=4.02u as=2.275p ps=8.3u w=3.5u l=1u
C0 w_n230_n138# a_542_0# 0.00675f
C1 a_950_n60# a_646_n60# 0.04083f
C2 w_n230_n138# a_n92_0# 0.03476f
C3 a_238_0# a_542_0# 0.11365f
C4 w_n230_n138# a_238_0# 0.00675f
C5 a_n92_0# a_238_0# 0.10459f
C6 a_846_0# a_950_n60# 0.06632f
C7 a_542_0# a_342_n60# 0.06632f
C8 w_n230_n138# a_342_n60# 0.19187f
C9 a_238_0# a_342_n60# 0.06632f
C10 a_542_0# a_646_n60# 0.06632f
C11 a_846_0# a_1150_0# 0.10459f
C12 w_n230_n138# a_646_n60# 0.19187f
C13 a_846_0# a_542_0# 0.11365f
C14 a_1150_0# a_950_n60# 0.05833f
C15 w_n230_n138# a_38_n60# 0.20722f
C16 w_n230_n138# a_846_0# 0.00675f
C17 a_n92_0# a_38_n60# 0.05833f
C18 a_342_n60# a_646_n60# 0.04083f
C19 a_38_n60# a_238_0# 0.06632f
C20 w_n230_n138# a_950_n60# 0.21243f
C21 a_38_n60# a_342_n60# 0.04083f
C22 w_n230_n138# a_1150_0# 0.41937f
C23 a_846_0# a_646_n60# 0.06632f
C24 a_1150_0# VSUBS 0.02006f
C25 a_846_0# VSUBS 0.02006f
C26 a_542_0# VSUBS 0.02006f
C27 a_238_0# VSUBS 0.02006f
C28 a_n92_0# VSUBS 0.10586f
C29 a_950_n60# VSUBS 0.2103f
C30 a_646_n60# VSUBS 0.19757f
C31 a_342_n60# VSUBS 0.19757f
C32 a_38_n60# VSUBS 0.21551f
C33 w_n230_n138# VSUBS 5.33893f
.ends

.subckt Pmos_Comparator vdd vout inp vss inn iref
Xpfet_0 iref iref vdd iref vdd vdd vss pfet
Xpfet$2_0 m1_n2024_n224# inn m1_n2024_n224# inn m1_n1530_320# inn m1_n1530_320# m1_n1530_320#
+ inn vdd vss pfet$2
Xpfet$2_1 m1_n442_n226# inp m1_n442_n226# inp m1_n1530_320# inp m1_n1530_320# m1_n1530_320#
+ inp vdd vss pfet$2
Xnfet_0 vss vss m1_n442_n226# m1_n2024_n224# nfet
Xnfet_1 vss vss m1_n442_n226# vout nfet
Xnfet_2 vss vss m1_n442_n226# m1_n442_n226# nfet
Xpfet$5_0 vdd m1_n3661_139# vdd m1_n3661_139# m1_n3661_139# vdd m1_n3661_139# m1_n3661_139#
+ m1_n3661_139# m1_n3661_139# m1_n3661_139# vdd vss pfet$5
Xpfet$5_1 vdd vout vdd m1_n3661_139# m1_n3661_139# vdd m1_n3661_139# vout m1_n3661_139#
+ m1_n3661_139# vout vdd vss pfet$5
Xnfet_3 vss vss m1_n2024_n224# m1_n442_n226# nfet
Xnfet_4 vss vss m1_n2024_n224# m1_n2024_n224# nfet
Xpfet$3_0 m1_n1530_320# iref m1_n1530_320# iref vdd iref vdd vdd iref vdd vss pfet$3
Xnfet_5 vss vss m1_n2024_n224# m1_n3661_139# nfet
C0 vdd m1_n3661_139# 1.93548f
C1 inn m1_n3661_139# 0.15848f
C2 inn vdd 0.17396f
C3 m1_n3661_139# m1_n442_n226# 0.00949f
C4 inp iref 0.02345f
C5 m1_n2024_n224# m1_n1530_320# 0.17345f
C6 vdd m1_n442_n226# 0.11621f
C7 vout m1_n1530_320# 0.00187f
C8 inn m1_n442_n226# 0.0319f
C9 vss m1_n1530_320# 0.00282f
C10 m1_n2024_n224# iref 0.00388f
C11 inp m1_n2024_n224# 0.20191f
C12 inp vout 0.01178f
C13 inp vss 0.20103f
C14 m1_n1530_320# m1_n3661_139# 0.16065f
C15 m1_n1530_320# vdd 0.93828f
C16 m1_n1530_320# inn 0.30843f
C17 vss m1_n2024_n224# 0.755f
C18 iref m1_n3661_139# 0.21525f
C19 vout vss 0.02866f
C20 m1_n1530_320# m1_n442_n226# 0.19769f
C21 iref vdd 1.77766f
C22 inp m1_n3661_139# 0.08168f
C23 iref inn 0.01707f
C24 inp vdd 0.08033f
C25 inp inn 0.95107f
C26 iref m1_n442_n226# 0.00981f
C27 m1_n2024_n224# m1_n3661_139# 0.06789f
C28 inp m1_n442_n226# 0.87146f
C29 vout m1_n3661_139# 0.25212f
C30 vss m1_n3661_139# 0.01015f
C31 m1_n2024_n224# vdd 0.11758f
C32 m1_n2024_n224# inn 0.81388f
C33 vout vdd 0.7523f
C34 vss inn 0.0176f
C35 m1_n2024_n224# m1_n442_n226# 0.47846f
C36 vout m1_n442_n226# 0.06014f
C37 vss m1_n442_n226# 0.87908f
C38 iref m1_n1530_320# 0.55128f
C39 inp m1_n1530_320# 0.32192f
C40 vss 0 9.36979f
C41 m1_n2024_n224# 0 2.11974f
C42 iref 0 2.12802f
C43 vdd 0 37.17121f
C44 m1_n3661_139# 0 4.00085f
C45 vout 0 0.97911f
C46 m1_n442_n226# 0 2.04404f
C47 inp 0 1.36394f
C48 m1_n1530_320# 0 1.44156f
C49 inn 0 1.17893f
.ends
