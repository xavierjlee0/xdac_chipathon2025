** sch_path: /foss/designs/libs/core_swmatrix/Angel_one_SW_block.sch
.subckt Angel_one_SW_block Pin Bus VDDd VSSd PHI_1 PHI_2 D_in Q EN
*.PININFO Pin:B Bus:B VDDd:B VSSd:B PHI_1:I PHI_2:I D_in:I Q:O EN:I
xTx_gate VDDd I Bus Pin VSSd transmission_gate_2
xFF D_in Q PHI_1 PHI_2 EN I VSSd DFF_2phase_1
.ends

* expanding   symbol:  libs/core_analog/tx_gate/transmission_gate_2.sym # of pins=5
** sym_path: /foss/designs/libs/core_analog/tx_gate/transmission_gate_2.sym
** sch_path: /foss/designs/libs/core_analog/tx_gate/transmission_gate_2.sch
.subckt transmission_gate_2 VDDd I Bus Pin VSSd
*.PININFO VDDd:B I:I Bus:O Pin:I VSSd:B
XM3 Bus I Pin VSSd nfet_03v3 L=0.28u W=6u nf=1 m=4
XM4 Bus net1 Pin VDDd pfet_03v3 L=0.28u W=6u nf=1 m=12
x1 I net1 VDDd VDDd VSSd VSSd gf180mcu_fd_sc_mcu9t5v0__inv_1
.ends

* expanding   symbol:  libs/core_swmatrix/DFF_2phase_1.sym # of pins=7
** sym_path: /foss/designs/libs/core_swmatrix/DFF_2phase_1.sym
** sch_path: /foss/designs/libs/core_swmatrix/DFF_2phase_1.sch
.subckt DFF_2phase_1 D Q PHI_1 PHI_2 EN I VSS
*.PININFO D:I PHI_1:I PHI_2:I Q:O EN:I I:O VSS:I
xmain D PHI_1 out_m VDDd VDDd VSSd VSSd gf180mcu_fd_sc_mcu9t5v0__latq_1
xsecondary out_m PHI_2 Q VDDd VDDd VSSd VSSd gf180mcu_fd_sc_mcu9t5v0__latq_1
x2 EN Q net1 VDDd VDDd VSSd VSSd gf180mcu_fd_sc_mcu9t5v0__nand2_1
x3 net1 I VDDd VDDd VSSd VSSd gf180mcu_fd_sc_mcu9t5v0__inv_1
* noconn VSS
.ends
