** sch_path: /foss/designs/libs/core_analog/Comparator/Nmos_Comparator.sch
.subckt Nmos_Comparator vdd vout inp vss inn iref
*.PININFO vss:I vdd:I iref:I inn:I inp:I vout:O
M3 net1 net1 vss vss nfet_03v3 L=1u W=3.5u nf=1 m=1
M4 vout net1 vss vss nfet_03v3 L=1u W=3.5u nf=1 m=1
M5 net2 inn net3 vss nfet_03v3 L=1u W=4u nf=1 m=1
M6 net4 inp net3 vss nfet_03v3 L=1u W=4u nf=1 m=1
M7 net1 net2 vdd vdd pfet_03v3 L=0.5u W=16.5u nf=4 m=1
M9 net4 net4 vdd vdd pfet_03v3 L=0.5u W=10u nf=2 m=1
M11 net2 net2 vdd vdd pfet_03v3 L=0.5u W=10u nf=2 m=1
M12 vout net4 vdd vdd pfet_03v3 L=0.5u W=16.5u nf=4 m=1
M1 net4 net2 vdd vdd pfet_03v3 L=0.5u W=10u nf=2 m=1
M2 net2 net4 vdd vdd pfet_03v3 L=0.5u W=10u nf=2 m=1
M8 iref iref vss vss nfet_03v3 L=1u W=2.5u nf=1 m=1
M10 net3 iref vss vss nfet_03v3 L=1u W=5u nf=2 m=1
.ends
