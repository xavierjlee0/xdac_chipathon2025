* Extracted by KLayout with GF180MCU LVS runset on : 08/09/2025 23:29

.SUBCKT transmission_gate_2 VDD Pin Bus Control_Not|ZN I VSS
M$1 Bus Control_Not|ZN Pin VDD pfet_03v3 L=0.28U W=72U AS=21.06P AD=21.06P
+ PS=85.02U PD=85.02U
M$13 VDD I Control_Not|ZN VDD pfet_05v0 L=0.5U W=1.83U AS=0.8052P AD=0.8052P
+ PS=4.54U PD=4.54U
M$14 Bus I Pin VSS nfet_03v3 L=0.28U W=24U AS=8.34P AD=8.34P PS=32.78U PD=32.78U
M$18 VSS I Control_Not|ZN VSS nfet_05v0 L=0.6U W=1.32U AS=0.5808P AD=0.5808P
+ PS=3.52U PD=3.52U
.ENDS transmission_gate_2
