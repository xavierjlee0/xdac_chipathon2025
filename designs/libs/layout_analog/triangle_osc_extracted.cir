* Extracted by KLayout with GF180MCU LVS runset on : 11/09/2025 20:32

.SUBCKT triangle_osc vdd ibias_p ibias_compp v_7_3_p vcompp v_5_11_p v_6_9_p
+ v_4_1_pn vlo out iref vss vssd vddd v_8_7 q nq v_5_6 i_bias_n ibias_compn vho
+ v_3_7_n v_5_11_n v_6_9_n vcompn
M$1 ibias_compp ibias_compp vdd vdd pfet_03v3 L=1U W=7U AS=3.185P AD=3.185P
+ PS=12.32U PD=12.32U
M$3 ibias_p ibias_compp vdd vdd pfet_03v3 L=1U W=14U AS=5.005P AD=5.005P
+ PS=20.36U PD=20.36U
M$7 vdd v_7_3_p v_7_3_p vdd pfet_03v3 L=0.6U W=25U AS=8.45P AD=8.45P PS=33.38U
+ PD=33.38U
M$12 vcompp v_7_3_p vdd vdd pfet_03v3 L=0.6U W=25U AS=8.45P AD=8.45P PS=33.38U
+ PD=33.38U
M$17 v_5_11_p vlo ibias_p vdd pfet_03v3 L=1U W=12U AS=4.29P AD=4.29P PS=17.86U
+ PD=17.86U
M$21 v_6_9_p out ibias_p vdd pfet_03v3 L=1U W=12U AS=4.29P AD=4.29P PS=17.86U
+ PD=17.86U
M$25 vdd v_4_1_pn ibias_compn vdd pfet_03v3 L=1U W=4.5U AS=2.925P AD=2.925P
+ PS=10.3U PD=10.3U
M$26 v_5_6 nq out vdd pfet_03v3 L=0.3U W=8U AS=5.2P AD=5.2P PS=18.6U PD=18.6U
M$28 vdd v_4_1_pn v_5_6 vdd pfet_03v3 L=1U W=13.5U AS=8.775P AD=8.775P PS=30.9U
+ PD=30.9U
M$31 v_5_11_n v_5_11_n vdd vdd pfet_03v3 L=0.5U W=10U AS=4.55P AD=4.55P
+ PS=16.82U PD=16.82U
M$33 v_6_9_n v_5_11_n vdd vdd pfet_03v3 L=0.5U W=10U AS=4.55P AD=4.55P
+ PS=16.82U PD=16.82U
M$35 v_3_7_n v_5_11_n vdd vdd pfet_03v3 L=0.5U W=16.5U AS=7.5075P AD=7.5075P
+ PS=26.57U PD=26.57U
M$37 v_5_11_n v_6_9_n vdd vdd pfet_03v3 L=0.5U W=10U AS=4.55P AD=4.55P
+ PS=16.82U PD=16.82U
M$39 v_6_9_n v_6_9_n vdd vdd pfet_03v3 L=0.5U W=10U AS=4.55P AD=4.55P PS=16.82U
+ PD=16.82U
M$41 vcompn v_6_9_n vdd vdd pfet_03v3 L=0.5U W=16.5U AS=7.5075P AD=7.5075P
+ PS=26.57U PD=26.57U
M$43 vdd v_4_1_pn v_4_1_pn vdd pfet_03v3 L=1U W=13.5U AS=8.775P AD=8.775P
+ PS=30.9U PD=30.9U
M$46 q nq vddd vddd pfet_05v0 L=0.5U W=3.29U AS=1.1515P AD=1.1515P PS=6.335U
+ PD=6.335U
M$47 vddd vcompp q vddd pfet_05v0 L=0.5U W=3.29U AS=0.8554P AD=0.8554P PS=4.33U
+ PD=4.33U
M$50 nq q vddd vddd pfet_05v0 L=0.5U W=3.29U AS=1.1515P AD=1.1515P PS=6.335U
+ PD=6.335U
M$51 vddd vcompn nq vddd pfet_05v0 L=0.5U W=3.29U AS=0.8554P AD=0.8554P
+ PS=4.33U PD=4.33U
M$54 v_4_1_pn iref vss vss nfet_03v3 L=1U W=7.5U AS=4.575P AD=4.575P PS=18.66U
+ PD=18.66U
M$57 v_8_7 iref vss vss nfet_03v3 L=1U W=7.5U AS=4.575P AD=4.575P PS=18.66U
+ PD=18.66U
M$60 vss v_5_11_p v_7_3_p vss nfet_03v3 L=1U W=5.5U AS=3.355P AD=3.355P
+ PS=12.22U PD=12.22U
M$61 v_5_11_p v_5_11_p vss vss nfet_03v3 L=1U W=5.5U AS=3.355P AD=3.355P
+ PS=12.22U PD=12.22U
M$62 vss v_6_9_p v_5_11_p vss nfet_03v3 L=1U W=5.5U AS=3.355P AD=3.355P
+ PS=12.22U PD=12.22U
M$63 v_6_9_p v_5_11_p vss vss nfet_03v3 L=1U W=5.5U AS=3.355P AD=3.355P
+ PS=12.22U PD=12.22U
M$64 vss v_6_9_p v_6_9_p vss nfet_03v3 L=1U W=5.5U AS=3.355P AD=3.355P
+ PS=12.22U PD=12.22U
M$65 vcompp v_6_9_p vss vss nfet_03v3 L=1U W=5.5U AS=3.355P AD=3.355P PS=12.22U
+ PD=12.22U
M$66 iref iref vss vss nfet_03v3 L=1U W=2.5U AS=1.525P AD=1.525P PS=6.22U
+ PD=6.22U
M$67 vss iref ibias_compp vss nfet_03v3 L=1U W=2.5U AS=1.525P AD=1.525P
+ PS=6.22U PD=6.22U
M$68 v_8_7 nq out vss nfet_03v3 L=0.3U W=4U AS=2.44P AD=2.44P PS=9.22U PD=9.22U
M$69 i_bias_n ibias_compn vss vss nfet_03v3 L=1U W=5U AS=2.175P AD=2.175P
+ PS=9.24U PD=9.24U
M$71 ibias_compn ibias_compn vss vss nfet_03v3 L=1U W=2.5U AS=1.525P AD=1.525P
+ PS=6.22U PD=6.22U
M$72 vss v_3_7_n v_3_7_n vss nfet_03v3 L=1U W=3.5U AS=2.135P AD=2.135P PS=8.22U
+ PD=8.22U
M$73 vcompn v_3_7_n vss vss nfet_03v3 L=1U W=3.5U AS=2.135P AD=2.135P PS=8.22U
+ PD=8.22U
M$74 i_bias_n out v_5_11_n vss nfet_03v3 L=1U W=4U AS=2.44P AD=2.44P PS=9.22U
+ PD=9.22U
M$75 v_6_9_n vho i_bias_n vss nfet_03v3 L=1U W=4U AS=2.44P AD=2.44P PS=9.22U
+ PD=9.22U
M$76 \$36 nq vssd vss nfet_05v0 L=0.6U W=1.32U AS=0.5808P AD=0.2112P PS=3.52U
+ PD=1.64U
M$77 q vcompp \$36 vss nfet_05v0 L=0.6U W=1.32U AS=0.2112P AD=0.3432P PS=1.64U
+ PD=1.84U
M$78 \$45 vcompp q vss nfet_05v0 L=0.6U W=1.32U AS=0.3432P AD=0.2112P PS=1.84U
+ PD=1.64U
M$79 vssd nq \$45 vss nfet_05v0 L=0.6U W=1.32U AS=0.2112P AD=0.5808P PS=1.64U
+ PD=3.52U
M$80 \$57 q vssd vss nfet_05v0 L=0.6U W=1.32U AS=0.5808P AD=0.2112P PS=3.52U
+ PD=1.64U
M$81 nq vcompn \$57 vss nfet_05v0 L=0.6U W=1.32U AS=0.2112P AD=0.3432P PS=1.64U
+ PD=1.84U
M$82 \$58 vcompn nq vss nfet_05v0 L=0.6U W=1.32U AS=0.3432P AD=0.2112P PS=1.84U
+ PD=1.64U
M$83 vssd q \$58 vss nfet_05v0 L=0.6U W=1.32U AS=0.2112P AD=0.5808P PS=1.64U
+ PD=3.52U
.ENDS triangle_osc
