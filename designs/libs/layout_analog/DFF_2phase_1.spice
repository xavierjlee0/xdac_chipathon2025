** sch_path: /foss/designs/libs/core_swmatrix/DFF_2phase_1.sch
.subckt DFF_2phase_1 D Q PHI_1 PHI_2 EN I VSSd VDDd
*.PININFO D:I PHI_1:I PHI_2:I Q:O EN:I I:O VSSd:I VDDd:I
xmain D PHI_1 out_m VDDd VDDd VSSd VSSd gf180mcu_fd_sc_mcu9t5v0__latq_1
xsecondary out_m PHI_2 Q VDDd VDDd VSSd VSSd gf180mcu_fd_sc_mcu9t5v0__latq_1
x2 EN Q net1 VDDd VDDd VSSd VSSd gf180mcu_fd_sc_mcu9t5v0__nand2_1
x3 net1 I VDDd VDDd VSSd VSSd gf180mcu_fd_sc_mcu9t5v0__inv_1
* noconn VSSd
* noconn VDDd
.ends
