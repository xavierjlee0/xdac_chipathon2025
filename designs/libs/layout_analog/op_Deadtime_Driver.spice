* NGSPICE file created from op_Deadtime_Driver.ext - technology: gf180mcuD

.subckt nand2_1$1 VNW VPW a_2809_3578# a_2709_3030# a_2829_3074# a_2621_3074# a_2893_3030#
+ a_2621_3578#
X0 a_2621_3578# a_2893_3030# a_2809_3578# VNW pfet_05v0 ad=0.7238p pd=4.17u as=0.4277p ps=2.165u w=1.645u l=0.5u
X1 a_2809_3578# a_2893_3030# a_2829_3074# VPW nfet_05v0 ad=0.5808p pd=3.52u as=0.2112p ps=1.64u w=1.32u l=0.6u
X2 a_2809_3578# a_2709_3030# a_2621_3578# VNW pfet_05v0 ad=0.4277p pd=2.165u as=0.7238p ps=4.17u w=1.645u l=0.5u
X3 a_2829_3074# a_2709_3030# a_2621_3074# VPW nfet_05v0 ad=0.2112p pd=1.64u as=0.5808p ps=3.52u w=1.32u l=0.6u
C0 a_2809_3578# a_2829_3074# 0.00977f
C1 a_2893_3030# a_2621_3578# 0.02477f
C2 a_2709_3030# a_2621_3578# 0.03828f
C3 a_2809_3578# a_2621_3578# 0.13363f
C4 VNW a_2621_3074# 0.0063f
C5 a_2893_3030# a_2709_3030# 0.07455f
C6 a_2893_3030# a_2809_3578# 0.39638f
C7 a_2621_3074# a_2829_3074# 0.00659f
C8 a_2809_3578# a_2709_3030# 0.02759f
C9 a_2621_3074# a_2621_3578# 0.01677f
C10 VNW a_2621_3578# 0.09858f
C11 a_2893_3030# a_2621_3074# 0.02816f
C12 a_2829_3074# a_2621_3578# 0
C13 a_2893_3030# VNW 0.12344f
C14 a_2621_3074# a_2709_3030# 0.04633f
C15 VNW a_2709_3030# 0.1273f
C16 a_2621_3074# a_2809_3578# 0.1374f
C17 VNW a_2809_3578# 0.02887f
C18 VNW VPW 1.40764f
C19 a_2621_3074# VPW 0.2977f
C20 a_2809_3578# VPW 0.1743f
C21 a_2621_3578# VPW 0.24953f
C22 a_2893_3030# VPW 0.28278f
C23 a_2709_3030# VPW 0.31016f
.ends

.subckt inv_8$1 VNW VPW a_4630_5296# a_4818_5296# a_4718_4748# a_4630_4792#
X0 a_4818_5296# a_4718_4748# a_4630_5296# VNW pfet_05v0 ad=0.5673p pd=2.45u as=0.8052p ps=4.54u w=1.83u l=0.5u
X1 a_4630_5296# a_4718_4748# a_4818_5296# VNW pfet_05v0 ad=0.5673p pd=2.45u as=0.5673p ps=2.45u w=1.83u l=0.5u
X2 a_4818_5296# a_4718_4748# a_4630_4792# VPW nfet_05v0 ad=0.3432p pd=1.84u as=0.5808p ps=3.52u w=1.32u l=0.6u
X3 a_4630_5296# a_4718_4748# a_4818_5296# VNW pfet_05v0 ad=0.5673p pd=2.45u as=0.5673p ps=2.45u w=1.83u l=0.5u
X4 a_4818_5296# a_4718_4748# a_4630_5296# VNW pfet_05v0 ad=0.5673p pd=2.45u as=0.5673p ps=2.45u w=1.83u l=0.5u
X5 a_4630_4792# a_4718_4748# a_4818_5296# VPW nfet_05v0 ad=0.3432p pd=1.84u as=0.3432p ps=1.84u w=1.32u l=0.6u
X6 a_4630_4792# a_4718_4748# a_4818_5296# VPW nfet_05v0 ad=0.3432p pd=1.84u as=0.3432p ps=1.84u w=1.32u l=0.6u
X7 a_4818_5296# a_4718_4748# a_4630_4792# VPW nfet_05v0 ad=0.3432p pd=1.84u as=0.3432p ps=1.84u w=1.32u l=0.6u
X8 a_4818_5296# a_4718_4748# a_4630_5296# VNW pfet_05v0 ad=0.5673p pd=2.45u as=0.5673p ps=2.45u w=1.83u l=0.5u
X9 a_4630_5296# a_4718_4748# a_4818_5296# VNW pfet_05v0 ad=0.8052p pd=4.54u as=0.5673p ps=2.45u w=1.83u l=0.5u
X10 a_4818_5296# a_4718_4748# a_4630_4792# VPW nfet_05v0 ad=0.3432p pd=1.84u as=0.3432p ps=1.84u w=1.32u l=0.6u
X11 a_4630_5296# a_4718_4748# a_4818_5296# VNW pfet_05v0 ad=0.5673p pd=2.45u as=0.5673p ps=2.45u w=1.83u l=0.5u
X12 a_4818_5296# a_4718_4748# a_4630_5296# VNW pfet_05v0 ad=0.5673p pd=2.45u as=0.5673p ps=2.45u w=1.83u l=0.5u
X13 a_4630_4792# a_4718_4748# a_4818_5296# VPW nfet_05v0 ad=0.5808p pd=3.52u as=0.3432p ps=1.84u w=1.32u l=0.6u
X14 a_4630_4792# a_4718_4748# a_4818_5296# VPW nfet_05v0 ad=0.3432p pd=1.84u as=0.3432p ps=1.84u w=1.32u l=0.6u
X15 a_4818_5296# a_4718_4748# a_4630_4792# VPW nfet_05v0 ad=0.3432p pd=1.84u as=0.3432p ps=1.84u w=1.32u l=0.6u
C0 a_4718_4748# a_4630_5296# 0.31761f
C1 a_4818_5296# a_4630_5296# 1.00207f
C2 VNW a_4630_5296# 0.24996f
C3 a_4718_4748# a_4818_5296# 2.50272f
C4 VNW a_4718_4748# 1.13776f
C5 VNW a_4818_5296# 0.02955f
C6 a_4630_4792# a_4630_5296# 0.02916f
C7 a_4718_4748# a_4630_4792# 0.34774f
C8 a_4630_4792# a_4818_5296# 0.85494f
C9 VNW a_4630_4792# 0.01237f
C10 VNW VPW 4.20752f
C11 a_4630_4792# VPW 0.85221f
C12 a_4818_5296# VPW 0.23853f
C13 a_4630_5296# VPW 0.61194f
C14 a_4718_4748# VPW 2.32007f
.ends

.subckt nand2_1 VNW VPW a_2809_3578# a_2709_3030# a_2829_3074# a_2621_3074# a_2893_3030#
+ a_2621_3578#
X0 a_2621_3578# a_2893_3030# a_2809_3578# VNW pfet_05v0 ad=0.7238p pd=4.17u as=0.4277p ps=2.165u w=1.645u l=0.5u
X1 a_2809_3578# a_2893_3030# a_2829_3074# VPW nfet_05v0 ad=0.5808p pd=3.52u as=0.2112p ps=1.64u w=1.32u l=0.6u
X2 a_2809_3578# a_2709_3030# a_2621_3578# VNW pfet_05v0 ad=0.4277p pd=2.165u as=0.7238p ps=4.17u w=1.645u l=0.5u
X3 a_2829_3074# a_2709_3030# a_2621_3074# VPW nfet_05v0 ad=0.2112p pd=1.64u as=0.5808p ps=3.52u w=1.32u l=0.6u
C0 a_2621_3578# a_2621_3074# 0.01677f
C1 a_2829_3074# a_2621_3074# 0.00659f
C2 a_2709_3030# a_2893_3030# 0.07455f
C3 VNW a_2893_3030# 0.12344f
C4 a_2621_3578# a_2893_3030# 0.02477f
C5 VNW a_2709_3030# 0.1273f
C6 a_2709_3030# a_2621_3578# 0.03828f
C7 a_2809_3578# a_2621_3074# 0.1374f
C8 VNW a_2621_3578# 0.09858f
C9 a_2829_3074# a_2621_3578# 0
C10 a_2809_3578# a_2893_3030# 0.39638f
C11 a_2709_3030# a_2809_3578# 0.02759f
C12 a_2621_3074# a_2893_3030# 0.02816f
C13 VNW a_2809_3578# 0.02887f
C14 a_2809_3578# a_2621_3578# 0.13363f
C15 a_2709_3030# a_2621_3074# 0.04633f
C16 a_2829_3074# a_2809_3578# 0.00977f
C17 VNW a_2621_3074# 0.0063f
C18 VNW VPW 1.40764f
C19 a_2621_3074# VPW 0.2977f
C20 a_2809_3578# VPW 0.1743f
C21 a_2621_3578# VPW 0.24953f
C22 a_2893_3030# VPW 0.28278f
C23 a_2709_3030# VPW 0.31016f
.ends

.subckt inv_1 VNW VPW a_3844_3074# a_4052_3074# a_3864_3578# a_3932_3030#
X0 a_4052_3074# a_3932_3030# a_3844_3074# VPW nfet_05v0 ad=0.5808p pd=3.52u as=0.5808p ps=3.52u w=1.32u l=0.6u
X1 a_4052_3074# a_3932_3030# a_3864_3578# VNW pfet_05v0 ad=0.8052p pd=4.54u as=0.8052p ps=4.54u w=1.83u l=0.5u
C0 a_3864_3578# a_3844_3074# 0.02081f
C1 a_3864_3578# a_3932_3030# 0.04507f
C2 VNW a_4052_3074# 0.03301f
C3 a_4052_3074# a_3844_3074# 0.11108f
C4 VNW a_3844_3074# 0.01055f
C5 a_4052_3074# a_3932_3030# 0.27888f
C6 VNW a_3932_3030# 0.13191f
C7 a_3844_3074# a_3932_3030# 0.12034f
C8 a_4052_3074# a_3864_3578# 0.11292f
C9 VNW a_3864_3578# 0.08967f
C10 VNW VPW 1.19226f
C11 a_3844_3074# VPW 0.28149f
C12 a_4052_3074# VPW 0.15838f
C13 a_3864_3578# VPW 0.20543f
C14 a_3932_3030# VPW 0.34978f
.ends

.subckt inv_1$1 VNW VPW a_3844_3074# a_4052_3074# a_3864_3578# a_3932_3030#
X0 a_4052_3074# a_3932_3030# a_3844_3074# VPW nfet_05v0 ad=0.5808p pd=3.52u as=0.5808p ps=3.52u w=1.32u l=0.6u
X1 a_4052_3074# a_3932_3030# a_3864_3578# VNW pfet_05v0 ad=0.8052p pd=4.54u as=0.8052p ps=4.54u w=1.83u l=0.5u
C0 a_3864_3578# a_3844_3074# 0.02081f
C1 a_3864_3578# a_3932_3030# 0.04507f
C2 VNW a_4052_3074# 0.03301f
C3 a_4052_3074# a_3844_3074# 0.11108f
C4 VNW a_3844_3074# 0.01055f
C5 a_4052_3074# a_3932_3030# 0.27888f
C6 VNW a_3932_3030# 0.13191f
C7 a_3844_3074# a_3932_3030# 0.12034f
C8 a_4052_3074# a_3864_3578# 0.11292f
C9 VNW a_3864_3578# 0.08967f
C10 VNW VPW 1.19226f
C11 a_3844_3074# VPW 0.28149f
C12 a_4052_3074# VPW 0.15838f
C13 a_3864_3578# VPW 0.20543f
C14 a_3932_3030# VPW 0.34978f
.ends

.subckt inv_8 VNW VPW a_4630_5296# a_4818_5296# a_4718_4748# a_4630_4792#
X0 a_4818_5296# a_4718_4748# a_4630_5296# VNW pfet_05v0 ad=0.5673p pd=2.45u as=0.8052p ps=4.54u w=1.83u l=0.5u
X1 a_4630_5296# a_4718_4748# a_4818_5296# VNW pfet_05v0 ad=0.5673p pd=2.45u as=0.5673p ps=2.45u w=1.83u l=0.5u
X2 a_4818_5296# a_4718_4748# a_4630_4792# VPW nfet_05v0 ad=0.3432p pd=1.84u as=0.5808p ps=3.52u w=1.32u l=0.6u
X3 a_4630_5296# a_4718_4748# a_4818_5296# VNW pfet_05v0 ad=0.5673p pd=2.45u as=0.5673p ps=2.45u w=1.83u l=0.5u
X4 a_4818_5296# a_4718_4748# a_4630_5296# VNW pfet_05v0 ad=0.5673p pd=2.45u as=0.5673p ps=2.45u w=1.83u l=0.5u
X5 a_4630_4792# a_4718_4748# a_4818_5296# VPW nfet_05v0 ad=0.3432p pd=1.84u as=0.3432p ps=1.84u w=1.32u l=0.6u
X6 a_4630_4792# a_4718_4748# a_4818_5296# VPW nfet_05v0 ad=0.3432p pd=1.84u as=0.3432p ps=1.84u w=1.32u l=0.6u
X7 a_4818_5296# a_4718_4748# a_4630_4792# VPW nfet_05v0 ad=0.3432p pd=1.84u as=0.3432p ps=1.84u w=1.32u l=0.6u
X8 a_4818_5296# a_4718_4748# a_4630_5296# VNW pfet_05v0 ad=0.5673p pd=2.45u as=0.5673p ps=2.45u w=1.83u l=0.5u
X9 a_4630_5296# a_4718_4748# a_4818_5296# VNW pfet_05v0 ad=0.8052p pd=4.54u as=0.5673p ps=2.45u w=1.83u l=0.5u
X10 a_4818_5296# a_4718_4748# a_4630_4792# VPW nfet_05v0 ad=0.3432p pd=1.84u as=0.3432p ps=1.84u w=1.32u l=0.6u
X11 a_4630_5296# a_4718_4748# a_4818_5296# VNW pfet_05v0 ad=0.5673p pd=2.45u as=0.5673p ps=2.45u w=1.83u l=0.5u
X12 a_4818_5296# a_4718_4748# a_4630_5296# VNW pfet_05v0 ad=0.5673p pd=2.45u as=0.5673p ps=2.45u w=1.83u l=0.5u
X13 a_4630_4792# a_4718_4748# a_4818_5296# VPW nfet_05v0 ad=0.5808p pd=3.52u as=0.3432p ps=1.84u w=1.32u l=0.6u
X14 a_4630_4792# a_4718_4748# a_4818_5296# VPW nfet_05v0 ad=0.3432p pd=1.84u as=0.3432p ps=1.84u w=1.32u l=0.6u
X15 a_4818_5296# a_4718_4748# a_4630_4792# VPW nfet_05v0 ad=0.3432p pd=1.84u as=0.3432p ps=1.84u w=1.32u l=0.6u
C0 a_4630_5296# a_4630_4792# 0.02916f
C1 a_4630_5296# a_4718_4748# 0.31761f
C2 VNW a_4818_5296# 0.02955f
C3 a_4818_5296# a_4630_4792# 0.85494f
C4 VNW a_4630_4792# 0.01237f
C5 a_4818_5296# a_4718_4748# 2.50272f
C6 VNW a_4718_4748# 1.13776f
C7 a_4630_4792# a_4718_4748# 0.34774f
C8 a_4818_5296# a_4630_5296# 1.00207f
C9 VNW a_4630_5296# 0.24996f
C10 VNW VPW 4.20752f
C11 a_4630_4792# VPW 0.85221f
C12 a_4818_5296# VPW 0.23853f
C13 a_4630_5296# VPW 0.61194f
C14 a_4718_4748# VPW 2.32007f
.ends

.subckt cap_mim$1 m4_n120_n120# m4_0_0# VSUBS
X0 m4_0_0# m4_n120_n120# cap_mim_2f0_m4m5_noshield c_width=27u c_length=27u
C0 m4_0_0# m4_n120_n120# 1.59824f
C1 m4_0_0# VSUBS 8.67843f
C2 m4_n120_n120# VSUBS 3.67921f
.ends

.subckt op_Deadtime_Driver vout_pmos vin vout_nmos vss
Xnand2_1$1_0 inv_8_0/VNW vss m1_n6709_966# vin nand2_1$1_0/a_2829_3074# vss m1_n6954_761#
+ inv_8_0/VNW nand2_1$1
Xinv_8$1_0 inv_8_0/VNW vss inv_8_0/VNW vout_nmos m1_n6954_761# vss inv_8$1
Xnand2_1_0 inv_8_0/VNW vss m1_n6954_761# m1_n8216_n1245# nand2_1_0/a_2829_3074# vss
+ m1_n6709_966# inv_8_0/VNW nand2_1
Xinv_1_0 inv_8_0/VNW vss vss m1_757_773# inv_8_0/VNW m1_n6709_966# inv_1
Xinv_1$1_0 inv_8_0/VNW vss vss m1_n8216_n1245# inv_8_0/VNW vin inv_1$1
Xinv_8_0 inv_8_0/VNW vss inv_8_0/VNW vout_pmos m1_757_773# vss inv_8
Xcap_mim$1_0 vss m1_n6954_761# vss cap_mim$1
Xcap_mim$1_1 vss m1_n6709_966# vss cap_mim$1
C0 m1_n8216_n1245# vss 0.24278f
C1 m1_n8216_n1245# vin 0.02779f
C2 vss vin 0.28515f
C3 nand2_1_0/a_2829_3074# m1_n6709_966# 0.00166f
C4 m1_757_773# vss 0.24965f
C5 nand2_1$1_0/a_2829_3074# vss 0
C6 nand2_1_0/a_2829_3074# m1_n6954_761# 0
C7 m1_n8216_n1245# m1_n6709_966# 0.08741f
C8 m1_n8216_n1245# m1_n6954_761# 0.00405f
C9 m1_n6709_966# vss 2.28615f
C10 m1_n6709_966# vin 0.06264f
C11 vout_pmos inv_8_0/VNW 0.01796f
C12 vss m1_n6954_761# 2.36946f
C13 m1_n6954_761# vin 0.09522f
C14 vout_nmos vss 0.03598f
C15 m1_757_773# m1_n6709_966# 0.09355f
C16 nand2_1$1_0/a_2829_3074# m1_n6709_966# 0.00441f
C17 m1_757_773# m1_n6954_761# 0.00243f
C18 nand2_1$1_0/a_2829_3074# m1_n6954_761# 0
C19 vout_nmos m1_757_773# 0
C20 m1_n8216_n1245# inv_8_0/VNW 0.32862f
C21 m1_n6709_966# m1_n6954_761# 1.52144f
C22 vout_nmos m1_n6709_966# 0
C23 inv_8_0/VNW vss 1.30087f
C24 inv_8_0/VNW vin 0.93276f
C25 vout_nmos m1_n6954_761# 0.27122f
C26 m1_757_773# inv_8_0/VNW 0.64342f
C27 m1_n6709_966# inv_8_0/VNW 1.21773f
C28 vout_pmos vss 0.00592f
C29 m1_n8216_n1245# nand2_1_0/a_2829_3074# 0
C30 inv_8_0/VNW m1_n6954_761# 0.31702f
C31 vout_nmos inv_8_0/VNW 0.00768f
C32 vout_pmos m1_757_773# 0.26758f
C33 nand2_1_0/a_2829_3074# vss 0.00195f
C34 m1_n6954_761# 0 13.06471f
C35 vout_pmos 0 0.21223f
C36 vin 0 1.55438f
C37 m1_757_773# 0 3.20926f
C38 inv_8_0/VNW 0 33.21531f
C39 vss 0 13.22396f
C40 m1_n6709_966# 0 11.853f
C41 m1_n8216_n1245# 0 0.48442f
C42 vout_nmos 0 0.22528f
.ends
