** sch_path: /foss/designs/libs/core_analog/Comparator/Pmos_Comparator.sch
.subckt Pmos_Comparator vdd vout inp vss inn iref
*.PININFO vdd:I vss:I iref:I inn:I inp:I vout:O
M3 v_7_3_p v_7_3_p vdd vdd pfet_03v3 L=0.6u W=25u nf=5 m=1
M4 vout v_7_3_p vdd vdd pfet_03v3 L=0.6u W=25u nf=5 m=1
M5 v_5_11_p inn ibias_p vdd pfet_03v3 L=1u W=12u nf=4 m=1
M6 v_6_9_p inp ibias_p vdd pfet_03v3 L=1u W=12u nf=4 m=1
M7 v_7_3_p v_5_11_p vss vss nfet_03v3 L=1u W=5.5u nf=1 m=1
M8 v_5_11_p v_6_9_p vss vss nfet_03v3 L=1u W=5.5u nf=1 m=1
M9 v_6_9_p v_6_9_p vss vss nfet_03v3 L=1u W=5.5u nf=1 m=1
M10 v_6_9_p v_5_11_p vss vss nfet_03v3 L=1u W=5.5u nf=1 m=1
M11 v_5_11_p v_5_11_p vss vss nfet_03v3 L=1u W=5.5u nf=1 m=1
M12 vout v_6_9_p vss vss nfet_03v3 L=1u W=5.5u nf=1 m=1
M1 ibias_p iref vdd vdd pfet_03v3 L=1u W=14u nf=4 m=1
M2 iref iref vdd vdd pfet_03v3 L=1u W=7u nf=1 m=1
.ends
