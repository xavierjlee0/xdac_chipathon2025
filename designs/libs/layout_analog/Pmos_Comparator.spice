** sch_path: /foss/designs/libs/core_analog/Comparator/Pmos_Comparator.sch
.subckt Pmos_Comparator vdd vout inp vss inn iref
*.PININFO vdd:I vss:I iref:I inn:I inp:I vout:O
M3 net1 net1 vdd vdd pfet_03v3 L=0.6u W=25u nf=5 m=1
M4 vout net1 vdd vdd pfet_03v3 L=0.6u W=25u nf=5 m=1
M5 net2 inn net3 vdd pfet_03v3 L=1u W=12u nf=4 m=1
M6 net4 inp net3 vdd pfet_03v3 L=1u W=12u nf=4 m=1
M7 net1 net2 vss vss nfet_03v3 L=1u W=5.5u nf=1 m=1
M8 net2 net4 vss vss nfet_03v3 L=1u W=5.5u nf=1 m=1
M9 net4 net4 vss vss nfet_03v3 L=1u W=5.5u nf=1 m=1
M10 net4 net2 vss vss nfet_03v3 L=1u W=5.5u nf=1 m=1
M11 net2 net2 vss vss nfet_03v3 L=1u W=5.5u nf=1 m=1
M12 vout net4 vss vss nfet_03v3 L=1u W=5.5u nf=1 m=1
M1 net3 iref vdd vdd pfet_03v3 L=1u W=14u nf=4 m=1
M2 iref iref vdd vdd pfet_03v3 L=1u W=7u nf=1 m=1
.ends
