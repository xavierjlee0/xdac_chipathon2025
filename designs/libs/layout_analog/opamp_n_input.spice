** sch_path: /foss/designs/libs/core_analog/opamp/opamp_n_input.sch
.subckt opamp_n_input vinp vinn ibias vdd out vss
*.PININFO out:O vdd:I vss:I vinn:I ibias:I vinp:I
XM1 v_3_1 vinn viss vss nfet_03v3 L=1u W=3u nf=1 m=1
XM2 v_2_4 vinp viss vss nfet_03v3 L=1u W=3u nf=1 m=1
XM6 v_6_9 vg1 vdd vdd pfet_03v3 L=0.8u W=5u nf=1 m=5
XM5 vg1 vg1 vdd vdd pfet_03v3 L=0.8u W=5u nf=1 m=5
XM4 v_6_9 vb2 v_2_4 vss nfet_03v3 L=1u W=5u nf=1 m=6
XM3 vg1 vb2 v_3_1 vss nfet_03v3 L=1u W=5u nf=1 m=6
XM7 viss v_11_7 vss vss nfet_03v3 L=2u W=4.5u nf=1 m=3
XM11 v_11_7 v_11_7 vss vss nfet_03v3 L=2u W=4.5u nf=1 m=1
XM10 vb2 vb2 viss vss nfet_03v3 L=4u W=2u nf=1 m=1
XM8 out v_11_7 vss vss nfet_03v3 L=0.8u W=5.5u nf=1 m=2
XM9 out v_6_9 vdd vdd pfet_03v3 L=0.5u W=5.5u nf=1 m=14
XM12 v_16_12 v_16_12 v_11_7 vss nfet_03v3 L=2u W=4.5u nf=1 m=1
XM13 vb2 i_in vdd vdd pfet_03v3 L=1u W=3.5u nf=1 m=1
XM14 i_in i_in vdd vdd pfet_03v3 L=1u W=3.5u nf=1 m=1
XM15 ibias ibias i_in vdd pfet_03v3 L=1u W=3.5u nf=1 m=1
XM16 v_16_12 ibias v_17_16 vdd pfet_03v3 L=1u W=3.5u nf=1 m=1
XM17 v_17_16 i_in vdd vdd pfet_03v3 L=1u W=3.5u nf=1 m=1
XC3 v_2_4 out cap_mim_2f0fF c_width=25e-6 c_length=24e-6 m=1
.ends
