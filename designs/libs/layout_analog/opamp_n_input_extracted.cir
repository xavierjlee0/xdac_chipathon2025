* Extracted by KLayout with GF180MCU LVS runset on : 08/09/2025 08:04

.SUBCKT opamp_n_input vss out ibias vb2 vdd
M$1 \$21 ibias ibias vdd pfet_03v3 L=1U W=3.5U AS=2.275P AD=2.275P PS=8.3U
+ PD=8.3U
M$2 \$22 ibias \$11 vdd pfet_03v3 L=1U W=3.5U AS=2.275P AD=2.275P PS=8.3U
+ PD=8.3U
M$3 vdd \$21 vb2 vdd pfet_03v3 L=1U W=3.5U AS=2.275P AD=2.275P PS=8.3U PD=8.3U
M$4 vdd \$21 \$21 vdd pfet_03v3 L=1U W=3.5U AS=2.275P AD=2.275P PS=8.3U PD=8.3U
M$5 vdd \$21 \$22 vdd pfet_03v3 L=1U W=3.5U AS=2.275P AD=2.275P PS=8.3U PD=8.3U
M$6 vdd \$19 \$20 vdd pfet_03v3 L=0.8U W=25U AS=16.25P AD=16.25P PS=56.5U
+ PD=56.5U
M$8 vdd \$19 \$19 vdd pfet_03v3 L=0.8U W=25U AS=16.25P AD=16.25P PS=56.5U
+ PD=56.5U
M$10 vdd \$20 out vdd pfet_03v3 L=0.5U W=77U AS=50.05P AD=50.05P PS=172.2U
+ PD=172.2U
M$30 out \$4 vss vss nfet_03v3 L=0.8U W=11U AS=6.71P AD=6.71P PS=24.44U
+ PD=24.44U
M$31 \$4 \$4 vss vss nfet_03v3 L=2U W=4.5U AS=2.745P AD=2.745P PS=10.22U
+ PD=10.22U
M$32 \$6 \$4 vss vss nfet_03v3 L=2U W=13.5U AS=8.235P AD=8.235P PS=30.66U
+ PD=30.66U
M$36 \$11 \$11 \$4 vss nfet_03v3 L=2U W=4.5U AS=2.745P AD=2.745P PS=10.22U
+ PD=10.22U
M$37 \$25 \$12 \$6 vss nfet_03v3 L=1U W=3U AS=1.83P AD=1.83P PS=7.22U PD=7.22U
M$38 \$15 \$13 \$6 vss nfet_03v3 L=1U W=3U AS=1.83P AD=1.83P PS=7.22U PD=7.22U
M$39 \$25 vb2 \$19 vss nfet_03v3 L=1U W=30U AS=18.3P AD=18.3P PS=67.32U
+ PD=67.32U
M$42 \$15 vb2 \$20 vss nfet_03v3 L=1U W=30U AS=18.3P AD=18.3P PS=67.32U
+ PD=67.32U
M$45 vb2 vb2 \$6 vss nfet_03v3 L=4U W=2U AS=1.22P AD=1.22P PS=5.22U PD=5.22U
C$52 \$15 \$44 1.2e-12 cap_mim_2f0_m5m6_noshield A=600P P=98U
.ENDS opamp_n_input
