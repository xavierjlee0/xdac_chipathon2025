* NGSPICE file created from transmission_gate_2.ext - technology: gf180mcuD

.subckt inv_1 VNW VPW a_2374_6271# a_2254_6227# a_2166_6271# a_2186_6775#
X0 a_2374_6271# a_2254_6227# a_2166_6271# VPW nfet_05v0 ad=0.5808p pd=3.52u as=0.5808p ps=3.52u w=1.32u l=0.6u
X1 a_2374_6271# a_2254_6227# a_2186_6775# VNW pfet_05v0 ad=0.8052p pd=4.54u as=0.8052p ps=4.54u w=1.83u l=0.5u
.ends

.subckt nfet$1 a_30_1260# a_254_0# a_190_1260# a_350_1260# a_414_0# a_n84_0# a_94_0#
+ a_510_1260# a_574_0# a_696_0#
X0 a_254_0# a_190_1260# a_94_0# a_696_0# nfet_03v3 ad=1.56p pd=6.52u as=1.56p ps=6.52u w=6u l=0.28u
X1 a_574_0# a_510_1260# a_414_0# a_696_0# nfet_03v3 ad=3.66p pd=13.22u as=1.56p ps=6.52u w=6u l=0.28u
X2 a_94_0# a_30_1260# a_n84_0# a_696_0# nfet_03v3 ad=1.56p pd=6.52u as=3.66p ps=13.22u w=6u l=0.28u
X3 a_414_0# a_350_1260# a_254_0# a_696_0# nfet_03v3 ad=1.56p pd=6.52u as=1.56p ps=6.52u w=6u l=0.28u
.ends

.subckt pfet$1 a_1534_0# a_1054_0# a_734_0# a_508_1260# a_1694_0# a_254_0# a_1308_1260#
+ a_894_0# a_668_1260# a_1468_1260# a_1214_0# a_828_1260# a_28_1260# a_1854_0# a_414_0#
+ a_n92_0# a_1628_1260# a_1374_0# a_94_0# a_188_1260# a_574_0# a_988_1260# a_1788_1260#
+ a_348_1260# a_1148_1260# w_n230_n138#
X0 a_1214_0# a_1148_1260# a_1054_0# w_n230_n138# pfet_03v3 ad=1.56p pd=6.52u as=1.56p ps=6.52u w=6u l=0.28u
X1 a_734_0# a_668_1260# a_574_0# w_n230_n138# pfet_03v3 ad=1.56p pd=6.52u as=1.56p ps=6.52u w=6u l=0.28u
X2 a_254_0# a_188_1260# a_94_0# w_n230_n138# pfet_03v3 ad=1.56p pd=6.52u as=1.56p ps=6.52u w=6u l=0.28u
X3 a_574_0# a_508_1260# a_414_0# w_n230_n138# pfet_03v3 ad=1.56p pd=6.52u as=1.56p ps=6.52u w=6u l=0.28u
X4 a_1534_0# a_1468_1260# a_1374_0# w_n230_n138# pfet_03v3 ad=1.56p pd=6.52u as=1.56p ps=6.52u w=6u l=0.28u
X5 a_1374_0# a_1308_1260# a_1214_0# w_n230_n138# pfet_03v3 ad=1.56p pd=6.52u as=1.56p ps=6.52u w=6u l=0.28u
X6 a_1054_0# a_988_1260# a_894_0# w_n230_n138# pfet_03v3 ad=1.56p pd=6.52u as=1.56p ps=6.52u w=6u l=0.28u
X7 a_894_0# a_828_1260# a_734_0# w_n230_n138# pfet_03v3 ad=1.56p pd=6.52u as=1.56p ps=6.52u w=6u l=0.28u
X8 a_94_0# a_28_1260# a_n92_0# w_n230_n138# pfet_03v3 ad=1.56p pd=6.52u as=3.9p ps=13.3u w=6u l=0.28u
X9 a_414_0# a_348_1260# a_254_0# w_n230_n138# pfet_03v3 ad=1.56p pd=6.52u as=1.56p ps=6.52u w=6u l=0.28u
X10 a_1854_0# a_1788_1260# a_1694_0# w_n230_n138# pfet_03v3 ad=3.9p pd=13.3u as=1.56p ps=6.52u w=6u l=0.28u
X11 a_1694_0# a_1628_1260# a_1534_0# w_n230_n138# pfet_03v3 ad=1.56p pd=6.52u as=1.56p ps=6.52u w=6u l=0.28u
.ends

.subckt transmission_gate_2 VSSd VDDd I Pin ZN Bus
Xinv_1_0 VDDd VSSd ZN I VSSd VDDd inv_1
Xnfet$1_0 I Pin I I Bus Pin Bus I Pin VSSd nfet$1
Xpfet$1_0 Pin Bus Bus ZN Bus Pin ZN Pin ZN ZN Pin ZN ZN Pin Bus Pin ZN Bus Bus ZN
+ Pin ZN ZN ZN ZN VDDd pfet$1
.ends
