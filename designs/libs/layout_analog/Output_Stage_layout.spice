* NGSPICE file created from Output_Stage.ext - technology: gf180mcuD

.subckt pfet$3 a_28_1060# a_n92_0# a_94_0# w_n230_n138#
X0 a_94_0# a_28_1060# a_n92_0# w_n230_n138# pfet_03v3 ad=3.25p pd=11.3u as=3.25p ps=11.3u w=5u l=0.28u
.ends

.subckt Output_Stage_p$2 m1_1501_n36# m1_1393_1036# m1_n521_1120# m1_n409_30# pfet$3_0/a_n92_0#
Xpfet$3_0 m1_n521_1120# pfet$3_0/a_n92_0# m1_n409_30# m1_n409_30# pfet$3
Xpfet$3_1 m1_1393_1036# m1_1501_n36# m1_n409_30# m1_n409_30# pfet$3
.ends

.subckt nfet a_216_0# a_n84_0# a_94_0# a_30_1060#
X0 a_94_0# a_30_1060# a_n84_0# a_216_0# nfet_03v3 ad=3.05p pd=11.22u as=3.05p ps=11.22u w=5u l=0.28u
.ends

.subckt Output_Stage_n m1_2313_1219# m1_996_1314# nfet_0/a_n84_0# m1_2421_212# VSUBS
Xnfet_0 VSUBS nfet_0/a_n84_0# VSUBS m1_996_1314# nfet
Xnfet_1 VSUBS m1_2421_212# VSUBS m1_2313_1219# nfet
.ends

.subckt Output_Stage vout vdd vss vin_nmos vin_pmos
XOutput_Stage_p$2_0[0|0] vout vin_pmos vin_pmos vdd vout Output_Stage_p$2
XOutput_Stage_p$2_0[1|0] vout vin_pmos vin_pmos vdd vout Output_Stage_p$2
XOutput_Stage_p$2_0[2|0] vout vin_pmos vin_pmos vdd vout Output_Stage_p$2
XOutput_Stage_p$2_0[3|0] vout vin_pmos vin_pmos vdd vout Output_Stage_p$2
XOutput_Stage_p$2_0[4|0] vout vin_pmos vin_pmos vdd vout Output_Stage_p$2
XOutput_Stage_p$2_0[5|0] vout vin_pmos vin_pmos vdd vout Output_Stage_p$2
XOutput_Stage_p$2_0[6|0] vout vin_pmos vin_pmos vdd vout Output_Stage_p$2
XOutput_Stage_p$2_0[7|0] vout vin_pmos vin_pmos vdd vout Output_Stage_p$2
XOutput_Stage_p$2_0[8|0] vout vin_pmos vin_pmos vdd vout Output_Stage_p$2
XOutput_Stage_p$2_0[9|0] vout vin_pmos vin_pmos vdd vout Output_Stage_p$2
XOutput_Stage_p$2_0[10|0] vout vin_pmos vin_pmos vdd vout Output_Stage_p$2
XOutput_Stage_p$2_0[11|0] vout vin_pmos vin_pmos vdd vout Output_Stage_p$2
XOutput_Stage_p$2_0[12|0] vout vin_pmos vin_pmos vdd vout Output_Stage_p$2
XOutput_Stage_p$2_0[13|0] vout vin_pmos vin_pmos vdd vout Output_Stage_p$2
XOutput_Stage_p$2_0[14|0] vout vin_pmos vin_pmos vdd vout Output_Stage_p$2
XOutput_Stage_p$2_0[15|0] vout vin_pmos vin_pmos vdd vout Output_Stage_p$2
XOutput_Stage_p$2_0[0|1] vout vin_pmos vin_pmos vdd vout Output_Stage_p$2
XOutput_Stage_p$2_0[1|1] vout vin_pmos vin_pmos vdd vout Output_Stage_p$2
XOutput_Stage_p$2_0[2|1] vout vin_pmos vin_pmos vdd vout Output_Stage_p$2
XOutput_Stage_p$2_0[3|1] vout vin_pmos vin_pmos vdd vout Output_Stage_p$2
XOutput_Stage_p$2_0[4|1] vout vin_pmos vin_pmos vdd vout Output_Stage_p$2
XOutput_Stage_p$2_0[5|1] vout vin_pmos vin_pmos vdd vout Output_Stage_p$2
XOutput_Stage_p$2_0[6|1] vout vin_pmos vin_pmos vdd vout Output_Stage_p$2
XOutput_Stage_p$2_0[7|1] vout vin_pmos vin_pmos vdd vout Output_Stage_p$2
XOutput_Stage_p$2_0[8|1] vout vin_pmos vin_pmos vdd vout Output_Stage_p$2
XOutput_Stage_p$2_0[9|1] vout vin_pmos vin_pmos vdd vout Output_Stage_p$2
XOutput_Stage_p$2_0[10|1] vout vin_pmos vin_pmos vdd vout Output_Stage_p$2
XOutput_Stage_p$2_0[11|1] vout vin_pmos vin_pmos vdd vout Output_Stage_p$2
XOutput_Stage_p$2_0[12|1] vout vin_pmos vin_pmos vdd vout Output_Stage_p$2
XOutput_Stage_p$2_0[13|1] vout vin_pmos vin_pmos vdd vout Output_Stage_p$2
XOutput_Stage_p$2_0[14|1] vout vin_pmos vin_pmos vdd vout Output_Stage_p$2
XOutput_Stage_p$2_0[15|1] vout vin_pmos vin_pmos vdd vout Output_Stage_p$2
XOutput_Stage_p$2_0[0|2] vout vin_pmos vin_pmos vdd vout Output_Stage_p$2
XOutput_Stage_p$2_0[1|2] vout vin_pmos vin_pmos vdd vout Output_Stage_p$2
XOutput_Stage_p$2_0[2|2] vout vin_pmos vin_pmos vdd vout Output_Stage_p$2
XOutput_Stage_p$2_0[3|2] vout vin_pmos vin_pmos vdd vout Output_Stage_p$2
XOutput_Stage_p$2_0[4|2] vout vin_pmos vin_pmos vdd vout Output_Stage_p$2
XOutput_Stage_p$2_0[5|2] vout vin_pmos vin_pmos vdd vout Output_Stage_p$2
XOutput_Stage_p$2_0[6|2] vout vin_pmos vin_pmos vdd vout Output_Stage_p$2
XOutput_Stage_p$2_0[7|2] vout vin_pmos vin_pmos vdd vout Output_Stage_p$2
XOutput_Stage_p$2_0[8|2] vout vin_pmos vin_pmos vdd vout Output_Stage_p$2
XOutput_Stage_p$2_0[9|2] vout vin_pmos vin_pmos vdd vout Output_Stage_p$2
XOutput_Stage_p$2_0[10|2] vout vin_pmos vin_pmos vdd vout Output_Stage_p$2
XOutput_Stage_p$2_0[11|2] vout vin_pmos vin_pmos vdd vout Output_Stage_p$2
XOutput_Stage_p$2_0[12|2] vout vin_pmos vin_pmos vdd vout Output_Stage_p$2
XOutput_Stage_p$2_0[13|2] vout vin_pmos vin_pmos vdd vout Output_Stage_p$2
XOutput_Stage_p$2_0[14|2] vout vin_pmos vin_pmos vdd vout Output_Stage_p$2
XOutput_Stage_p$2_0[15|2] vout vin_pmos vin_pmos vdd vout Output_Stage_p$2
XOutput_Stage_p$2_0[0|3] vout vin_pmos vin_pmos vdd vout Output_Stage_p$2
XOutput_Stage_p$2_0[1|3] vout vin_pmos vin_pmos vdd vout Output_Stage_p$2
XOutput_Stage_p$2_0[2|3] vout vin_pmos vin_pmos vdd vout Output_Stage_p$2
XOutput_Stage_p$2_0[3|3] vout vin_pmos vin_pmos vdd vout Output_Stage_p$2
XOutput_Stage_p$2_0[4|3] vout vin_pmos vin_pmos vdd vout Output_Stage_p$2
XOutput_Stage_p$2_0[5|3] vout vin_pmos vin_pmos vdd vout Output_Stage_p$2
XOutput_Stage_p$2_0[6|3] vout vin_pmos vin_pmos vdd vout Output_Stage_p$2
XOutput_Stage_p$2_0[7|3] vout vin_pmos vin_pmos vdd vout Output_Stage_p$2
XOutput_Stage_p$2_0[8|3] vout vin_pmos vin_pmos vdd vout Output_Stage_p$2
XOutput_Stage_p$2_0[9|3] vout vin_pmos vin_pmos vdd vout Output_Stage_p$2
XOutput_Stage_p$2_0[10|3] vout vin_pmos vin_pmos vdd vout Output_Stage_p$2
XOutput_Stage_p$2_0[11|3] vout vin_pmos vin_pmos vdd vout Output_Stage_p$2
XOutput_Stage_p$2_0[12|3] vout vin_pmos vin_pmos vdd vout Output_Stage_p$2
XOutput_Stage_p$2_0[13|3] vout vin_pmos vin_pmos vdd vout Output_Stage_p$2
XOutput_Stage_p$2_0[14|3] vout vin_pmos vin_pmos vdd vout Output_Stage_p$2
XOutput_Stage_p$2_0[15|3] vout vin_pmos vin_pmos vdd vout Output_Stage_p$2
XOutput_Stage_p$2_0[0|4] vout vin_pmos vin_pmos vdd vout Output_Stage_p$2
XOutput_Stage_p$2_0[1|4] vout vin_pmos vin_pmos vdd vout Output_Stage_p$2
XOutput_Stage_p$2_0[2|4] vout vin_pmos vin_pmos vdd vout Output_Stage_p$2
XOutput_Stage_p$2_0[3|4] vout vin_pmos vin_pmos vdd vout Output_Stage_p$2
XOutput_Stage_p$2_0[4|4] vout vin_pmos vin_pmos vdd vout Output_Stage_p$2
XOutput_Stage_p$2_0[5|4] vout vin_pmos vin_pmos vdd vout Output_Stage_p$2
XOutput_Stage_p$2_0[6|4] vout vin_pmos vin_pmos vdd vout Output_Stage_p$2
XOutput_Stage_p$2_0[7|4] vout vin_pmos vin_pmos vdd vout Output_Stage_p$2
XOutput_Stage_p$2_0[8|4] vout vin_pmos vin_pmos vdd vout Output_Stage_p$2
XOutput_Stage_p$2_0[9|4] vout vin_pmos vin_pmos vdd vout Output_Stage_p$2
XOutput_Stage_p$2_0[10|4] vout vin_pmos vin_pmos vdd vout Output_Stage_p$2
XOutput_Stage_p$2_0[11|4] vout vin_pmos vin_pmos vdd vout Output_Stage_p$2
XOutput_Stage_p$2_0[12|4] vout vin_pmos vin_pmos vdd vout Output_Stage_p$2
XOutput_Stage_p$2_0[13|4] vout vin_pmos vin_pmos vdd vout Output_Stage_p$2
XOutput_Stage_p$2_0[14|4] vout vin_pmos vin_pmos vdd vout Output_Stage_p$2
XOutput_Stage_p$2_0[15|4] vout vin_pmos vin_pmos vdd vout Output_Stage_p$2
XOutput_Stage_p$2_0[0|5] vout vin_pmos vin_pmos vdd vout Output_Stage_p$2
XOutput_Stage_p$2_0[1|5] vout vin_pmos vin_pmos vdd vout Output_Stage_p$2
XOutput_Stage_p$2_0[2|5] vout vin_pmos vin_pmos vdd vout Output_Stage_p$2
XOutput_Stage_p$2_0[3|5] vout vin_pmos vin_pmos vdd vout Output_Stage_p$2
XOutput_Stage_p$2_0[4|5] vout vin_pmos vin_pmos vdd vout Output_Stage_p$2
XOutput_Stage_p$2_0[5|5] vout vin_pmos vin_pmos vdd vout Output_Stage_p$2
XOutput_Stage_p$2_0[6|5] vout vin_pmos vin_pmos vdd vout Output_Stage_p$2
XOutput_Stage_p$2_0[7|5] vout vin_pmos vin_pmos vdd vout Output_Stage_p$2
XOutput_Stage_p$2_0[8|5] vout vin_pmos vin_pmos vdd vout Output_Stage_p$2
XOutput_Stage_p$2_0[9|5] vout vin_pmos vin_pmos vdd vout Output_Stage_p$2
XOutput_Stage_p$2_0[10|5] vout vin_pmos vin_pmos vdd vout Output_Stage_p$2
XOutput_Stage_p$2_0[11|5] vout vin_pmos vin_pmos vdd vout Output_Stage_p$2
XOutput_Stage_p$2_0[12|5] vout vin_pmos vin_pmos vdd vout Output_Stage_p$2
XOutput_Stage_p$2_0[13|5] vout vin_pmos vin_pmos vdd vout Output_Stage_p$2
XOutput_Stage_p$2_0[14|5] vout vin_pmos vin_pmos vdd vout Output_Stage_p$2
XOutput_Stage_p$2_0[15|5] vout vin_pmos vin_pmos vdd vout Output_Stage_p$2
XOutput_Stage_p$2_0[0|6] vout vin_pmos vin_pmos vdd vout Output_Stage_p$2
XOutput_Stage_p$2_0[1|6] vout vin_pmos vin_pmos vdd vout Output_Stage_p$2
XOutput_Stage_p$2_0[2|6] vout vin_pmos vin_pmos vdd vout Output_Stage_p$2
XOutput_Stage_p$2_0[3|6] vout vin_pmos vin_pmos vdd vout Output_Stage_p$2
XOutput_Stage_p$2_0[4|6] vout vin_pmos vin_pmos vdd vout Output_Stage_p$2
XOutput_Stage_p$2_0[5|6] vout vin_pmos vin_pmos vdd vout Output_Stage_p$2
XOutput_Stage_p$2_0[6|6] vout vin_pmos vin_pmos vdd vout Output_Stage_p$2
XOutput_Stage_p$2_0[7|6] vout vin_pmos vin_pmos vdd vout Output_Stage_p$2
XOutput_Stage_p$2_0[8|6] vout vin_pmos vin_pmos vdd vout Output_Stage_p$2
XOutput_Stage_p$2_0[9|6] vout vin_pmos vin_pmos vdd vout Output_Stage_p$2
XOutput_Stage_p$2_0[10|6] vout vin_pmos vin_pmos vdd vout Output_Stage_p$2
XOutput_Stage_p$2_0[11|6] vout vin_pmos vin_pmos vdd vout Output_Stage_p$2
XOutput_Stage_p$2_0[12|6] vout vin_pmos vin_pmos vdd vout Output_Stage_p$2
XOutput_Stage_p$2_0[13|6] vout vin_pmos vin_pmos vdd vout Output_Stage_p$2
XOutput_Stage_p$2_0[14|6] vout vin_pmos vin_pmos vdd vout Output_Stage_p$2
XOutput_Stage_p$2_0[15|6] vout vin_pmos vin_pmos vdd vout Output_Stage_p$2
XOutput_Stage_p$2_0[0|7] vout vin_pmos vin_pmos vdd vout Output_Stage_p$2
XOutput_Stage_p$2_0[1|7] vout vin_pmos vin_pmos vdd vout Output_Stage_p$2
XOutput_Stage_p$2_0[2|7] vout vin_pmos vin_pmos vdd vout Output_Stage_p$2
XOutput_Stage_p$2_0[3|7] vout vin_pmos vin_pmos vdd vout Output_Stage_p$2
XOutput_Stage_p$2_0[4|7] vout vin_pmos vin_pmos vdd vout Output_Stage_p$2
XOutput_Stage_p$2_0[5|7] vout vin_pmos vin_pmos vdd vout Output_Stage_p$2
XOutput_Stage_p$2_0[6|7] vout vin_pmos vin_pmos vdd vout Output_Stage_p$2
XOutput_Stage_p$2_0[7|7] vout vin_pmos vin_pmos vdd vout Output_Stage_p$2
XOutput_Stage_p$2_0[8|7] vout vin_pmos vin_pmos vdd vout Output_Stage_p$2
XOutput_Stage_p$2_0[9|7] vout vin_pmos vin_pmos vdd vout Output_Stage_p$2
XOutput_Stage_p$2_0[10|7] vout vin_pmos vin_pmos vdd vout Output_Stage_p$2
XOutput_Stage_p$2_0[11|7] vout vin_pmos vin_pmos vdd vout Output_Stage_p$2
XOutput_Stage_p$2_0[12|7] vout vin_pmos vin_pmos vdd vout Output_Stage_p$2
XOutput_Stage_p$2_0[13|7] vout vin_pmos vin_pmos vdd vout Output_Stage_p$2
XOutput_Stage_p$2_0[14|7] vout vin_pmos vin_pmos vdd vout Output_Stage_p$2
XOutput_Stage_p$2_0[15|7] vout vin_pmos vin_pmos vdd vout Output_Stage_p$2
XOutput_Stage_p$2_0[0|8] vout vin_pmos vin_pmos vdd vout Output_Stage_p$2
XOutput_Stage_p$2_0[1|8] vout vin_pmos vin_pmos vdd vout Output_Stage_p$2
XOutput_Stage_p$2_0[2|8] vout vin_pmos vin_pmos vdd vout Output_Stage_p$2
XOutput_Stage_p$2_0[3|8] vout vin_pmos vin_pmos vdd vout Output_Stage_p$2
XOutput_Stage_p$2_0[4|8] vout vin_pmos vin_pmos vdd vout Output_Stage_p$2
XOutput_Stage_p$2_0[5|8] vout vin_pmos vin_pmos vdd vout Output_Stage_p$2
XOutput_Stage_p$2_0[6|8] vout vin_pmos vin_pmos vdd vout Output_Stage_p$2
XOutput_Stage_p$2_0[7|8] vout vin_pmos vin_pmos vdd vout Output_Stage_p$2
XOutput_Stage_p$2_0[8|8] vout vin_pmos vin_pmos vdd vout Output_Stage_p$2
XOutput_Stage_p$2_0[9|8] vout vin_pmos vin_pmos vdd vout Output_Stage_p$2
XOutput_Stage_p$2_0[10|8] vout vin_pmos vin_pmos vdd vout Output_Stage_p$2
XOutput_Stage_p$2_0[11|8] vout vin_pmos vin_pmos vdd vout Output_Stage_p$2
XOutput_Stage_p$2_0[12|8] vout vin_pmos vin_pmos vdd vout Output_Stage_p$2
XOutput_Stage_p$2_0[13|8] vout vin_pmos vin_pmos vdd vout Output_Stage_p$2
XOutput_Stage_p$2_0[14|8] vout vin_pmos vin_pmos vdd vout Output_Stage_p$2
XOutput_Stage_p$2_0[15|8] vout vin_pmos vin_pmos vdd vout Output_Stage_p$2
XOutput_Stage_p$2_0[0|9] vout vin_pmos vin_pmos vdd vout Output_Stage_p$2
XOutput_Stage_p$2_0[1|9] vout vin_pmos vin_pmos vdd vout Output_Stage_p$2
XOutput_Stage_p$2_0[2|9] vout vin_pmos vin_pmos vdd vout Output_Stage_p$2
XOutput_Stage_p$2_0[3|9] vout vin_pmos vin_pmos vdd vout Output_Stage_p$2
XOutput_Stage_p$2_0[4|9] vout vin_pmos vin_pmos vdd vout Output_Stage_p$2
XOutput_Stage_p$2_0[5|9] vout vin_pmos vin_pmos vdd vout Output_Stage_p$2
XOutput_Stage_p$2_0[6|9] vout vin_pmos vin_pmos vdd vout Output_Stage_p$2
XOutput_Stage_p$2_0[7|9] vout vin_pmos vin_pmos vdd vout Output_Stage_p$2
XOutput_Stage_p$2_0[8|9] vout vin_pmos vin_pmos vdd vout Output_Stage_p$2
XOutput_Stage_p$2_0[9|9] vout vin_pmos vin_pmos vdd vout Output_Stage_p$2
XOutput_Stage_p$2_0[10|9] vout vin_pmos vin_pmos vdd vout Output_Stage_p$2
XOutput_Stage_p$2_0[11|9] vout vin_pmos vin_pmos vdd vout Output_Stage_p$2
XOutput_Stage_p$2_0[12|9] vout vin_pmos vin_pmos vdd vout Output_Stage_p$2
XOutput_Stage_p$2_0[13|9] vout vin_pmos vin_pmos vdd vout Output_Stage_p$2
XOutput_Stage_p$2_0[14|9] vout vin_pmos vin_pmos vdd vout Output_Stage_p$2
XOutput_Stage_p$2_0[15|9] vout vin_pmos vin_pmos vdd vout Output_Stage_p$2
XOutput_Stage_p$2_0[0|10] vout vin_pmos vin_pmos vdd vout Output_Stage_p$2
XOutput_Stage_p$2_0[1|10] vout vin_pmos vin_pmos vdd vout Output_Stage_p$2
XOutput_Stage_p$2_0[2|10] vout vin_pmos vin_pmos vdd vout Output_Stage_p$2
XOutput_Stage_p$2_0[3|10] vout vin_pmos vin_pmos vdd vout Output_Stage_p$2
XOutput_Stage_p$2_0[4|10] vout vin_pmos vin_pmos vdd vout Output_Stage_p$2
XOutput_Stage_p$2_0[5|10] vout vin_pmos vin_pmos vdd vout Output_Stage_p$2
XOutput_Stage_p$2_0[6|10] vout vin_pmos vin_pmos vdd vout Output_Stage_p$2
XOutput_Stage_p$2_0[7|10] vout vin_pmos vin_pmos vdd vout Output_Stage_p$2
XOutput_Stage_p$2_0[8|10] vout vin_pmos vin_pmos vdd vout Output_Stage_p$2
XOutput_Stage_p$2_0[9|10] vout vin_pmos vin_pmos vdd vout Output_Stage_p$2
XOutput_Stage_p$2_0[10|10] vout vin_pmos vin_pmos vdd vout Output_Stage_p$2
XOutput_Stage_p$2_0[11|10] vout vin_pmos vin_pmos vdd vout Output_Stage_p$2
XOutput_Stage_p$2_0[12|10] vout vin_pmos vin_pmos vdd vout Output_Stage_p$2
XOutput_Stage_p$2_0[13|10] vout vin_pmos vin_pmos vdd vout Output_Stage_p$2
XOutput_Stage_p$2_0[14|10] vout vin_pmos vin_pmos vdd vout Output_Stage_p$2
XOutput_Stage_p$2_0[15|10] vout vin_pmos vin_pmos vdd vout Output_Stage_p$2
XOutput_Stage_p$2_0[0|11] vout vin_pmos vin_pmos vdd vout Output_Stage_p$2
XOutput_Stage_p$2_0[1|11] vout vin_pmos vin_pmos vdd vout Output_Stage_p$2
XOutput_Stage_p$2_0[2|11] vout vin_pmos vin_pmos vdd vout Output_Stage_p$2
XOutput_Stage_p$2_0[3|11] vout vin_pmos vin_pmos vdd vout Output_Stage_p$2
XOutput_Stage_p$2_0[4|11] vout vin_pmos vin_pmos vdd vout Output_Stage_p$2
XOutput_Stage_p$2_0[5|11] vout vin_pmos vin_pmos vdd vout Output_Stage_p$2
XOutput_Stage_p$2_0[6|11] vout vin_pmos vin_pmos vdd vout Output_Stage_p$2
XOutput_Stage_p$2_0[7|11] vout vin_pmos vin_pmos vdd vout Output_Stage_p$2
XOutput_Stage_p$2_0[8|11] vout vin_pmos vin_pmos vdd vout Output_Stage_p$2
XOutput_Stage_p$2_0[9|11] vout vin_pmos vin_pmos vdd vout Output_Stage_p$2
XOutput_Stage_p$2_0[10|11] vout vin_pmos vin_pmos vdd vout Output_Stage_p$2
XOutput_Stage_p$2_0[11|11] vout vin_pmos vin_pmos vdd vout Output_Stage_p$2
XOutput_Stage_p$2_0[12|11] vout vin_pmos vin_pmos vdd vout Output_Stage_p$2
XOutput_Stage_p$2_0[13|11] vout vin_pmos vin_pmos vdd vout Output_Stage_p$2
XOutput_Stage_p$2_0[14|11] vout vin_pmos vin_pmos vdd vout Output_Stage_p$2
XOutput_Stage_p$2_0[15|11] vout vin_pmos vin_pmos vdd vout Output_Stage_p$2
XOutput_Stage_p$2_0[0|12] vout vin_pmos vin_pmos vdd vout Output_Stage_p$2
XOutput_Stage_p$2_0[1|12] vout vin_pmos vin_pmos vdd vout Output_Stage_p$2
XOutput_Stage_p$2_0[2|12] vout vin_pmos vin_pmos vdd vout Output_Stage_p$2
XOutput_Stage_p$2_0[3|12] vout vin_pmos vin_pmos vdd vout Output_Stage_p$2
XOutput_Stage_p$2_0[4|12] vout vin_pmos vin_pmos vdd vout Output_Stage_p$2
XOutput_Stage_p$2_0[5|12] vout vin_pmos vin_pmos vdd vout Output_Stage_p$2
XOutput_Stage_p$2_0[6|12] vout vin_pmos vin_pmos vdd vout Output_Stage_p$2
XOutput_Stage_p$2_0[7|12] vout vin_pmos vin_pmos vdd vout Output_Stage_p$2
XOutput_Stage_p$2_0[8|12] vout vin_pmos vin_pmos vdd vout Output_Stage_p$2
XOutput_Stage_p$2_0[9|12] vout vin_pmos vin_pmos vdd vout Output_Stage_p$2
XOutput_Stage_p$2_0[10|12] vout vin_pmos vin_pmos vdd vout Output_Stage_p$2
XOutput_Stage_p$2_0[11|12] vout vin_pmos vin_pmos vdd vout Output_Stage_p$2
XOutput_Stage_p$2_0[12|12] vout vin_pmos vin_pmos vdd vout Output_Stage_p$2
XOutput_Stage_p$2_0[13|12] vout vin_pmos vin_pmos vdd vout Output_Stage_p$2
XOutput_Stage_p$2_0[14|12] vout vin_pmos vin_pmos vdd vout Output_Stage_p$2
XOutput_Stage_p$2_0[15|12] vout vin_pmos vin_pmos vdd vout Output_Stage_p$2
XOutput_Stage_p$2_0[0|13] vout vin_pmos vin_pmos vdd vout Output_Stage_p$2
XOutput_Stage_p$2_0[1|13] vout vin_pmos vin_pmos vdd vout Output_Stage_p$2
XOutput_Stage_p$2_0[2|13] vout vin_pmos vin_pmos vdd vout Output_Stage_p$2
XOutput_Stage_p$2_0[3|13] vout vin_pmos vin_pmos vdd vout Output_Stage_p$2
XOutput_Stage_p$2_0[4|13] vout vin_pmos vin_pmos vdd vout Output_Stage_p$2
XOutput_Stage_p$2_0[5|13] vout vin_pmos vin_pmos vdd vout Output_Stage_p$2
XOutput_Stage_p$2_0[6|13] vout vin_pmos vin_pmos vdd vout Output_Stage_p$2
XOutput_Stage_p$2_0[7|13] vout vin_pmos vin_pmos vdd vout Output_Stage_p$2
XOutput_Stage_p$2_0[8|13] vout vin_pmos vin_pmos vdd vout Output_Stage_p$2
XOutput_Stage_p$2_0[9|13] vout vin_pmos vin_pmos vdd vout Output_Stage_p$2
XOutput_Stage_p$2_0[10|13] vout vin_pmos vin_pmos vdd vout Output_Stage_p$2
XOutput_Stage_p$2_0[11|13] vout vin_pmos vin_pmos vdd vout Output_Stage_p$2
XOutput_Stage_p$2_0[12|13] vout vin_pmos vin_pmos vdd vout Output_Stage_p$2
XOutput_Stage_p$2_0[13|13] vout vin_pmos vin_pmos vdd vout Output_Stage_p$2
XOutput_Stage_p$2_0[14|13] vout vin_pmos vin_pmos vdd vout Output_Stage_p$2
XOutput_Stage_p$2_0[15|13] vout vin_pmos vin_pmos vdd vout Output_Stage_p$2
XOutput_Stage_p$2_0[0|14] vout vin_pmos vin_pmos vdd vout Output_Stage_p$2
XOutput_Stage_p$2_0[1|14] vout vin_pmos vin_pmos vdd vout Output_Stage_p$2
XOutput_Stage_p$2_0[2|14] vout vin_pmos vin_pmos vdd vout Output_Stage_p$2
XOutput_Stage_p$2_0[3|14] vout vin_pmos vin_pmos vdd vout Output_Stage_p$2
XOutput_Stage_p$2_0[4|14] vout vin_pmos vin_pmos vdd vout Output_Stage_p$2
XOutput_Stage_p$2_0[5|14] vout vin_pmos vin_pmos vdd vout Output_Stage_p$2
XOutput_Stage_p$2_0[6|14] vout vin_pmos vin_pmos vdd vout Output_Stage_p$2
XOutput_Stage_p$2_0[7|14] vout vin_pmos vin_pmos vdd vout Output_Stage_p$2
XOutput_Stage_p$2_0[8|14] vout vin_pmos vin_pmos vdd vout Output_Stage_p$2
XOutput_Stage_p$2_0[9|14] vout vin_pmos vin_pmos vdd vout Output_Stage_p$2
XOutput_Stage_p$2_0[10|14] vout vin_pmos vin_pmos vdd vout Output_Stage_p$2
XOutput_Stage_p$2_0[11|14] vout vin_pmos vin_pmos vdd vout Output_Stage_p$2
XOutput_Stage_p$2_0[12|14] vout vin_pmos vin_pmos vdd vout Output_Stage_p$2
XOutput_Stage_p$2_0[13|14] vout vin_pmos vin_pmos vdd vout Output_Stage_p$2
XOutput_Stage_p$2_0[14|14] vout vin_pmos vin_pmos vdd vout Output_Stage_p$2
XOutput_Stage_p$2_0[15|14] vout vin_pmos vin_pmos vdd vout Output_Stage_p$2
XOutput_Stage_p$2_0[0|15] vout vin_pmos vin_pmos vdd vout Output_Stage_p$2
XOutput_Stage_p$2_0[1|15] vout vin_pmos vin_pmos vdd vout Output_Stage_p$2
XOutput_Stage_p$2_0[2|15] vout vin_pmos vin_pmos vdd vout Output_Stage_p$2
XOutput_Stage_p$2_0[3|15] vout vin_pmos vin_pmos vdd vout Output_Stage_p$2
XOutput_Stage_p$2_0[4|15] vout vin_pmos vin_pmos vdd vout Output_Stage_p$2
XOutput_Stage_p$2_0[5|15] vout vin_pmos vin_pmos vdd vout Output_Stage_p$2
XOutput_Stage_p$2_0[6|15] vout vin_pmos vin_pmos vdd vout Output_Stage_p$2
XOutput_Stage_p$2_0[7|15] vout vin_pmos vin_pmos vdd vout Output_Stage_p$2
XOutput_Stage_p$2_0[8|15] vout vin_pmos vin_pmos vdd vout Output_Stage_p$2
XOutput_Stage_p$2_0[9|15] vout vin_pmos vin_pmos vdd vout Output_Stage_p$2
XOutput_Stage_p$2_0[10|15] vout vin_pmos vin_pmos vdd vout Output_Stage_p$2
XOutput_Stage_p$2_0[11|15] vout vin_pmos vin_pmos vdd vout Output_Stage_p$2
XOutput_Stage_p$2_0[12|15] vout vin_pmos vin_pmos vdd vout Output_Stage_p$2
XOutput_Stage_p$2_0[13|15] vout vin_pmos vin_pmos vdd vout Output_Stage_p$2
XOutput_Stage_p$2_0[14|15] vout vin_pmos vin_pmos vdd vout Output_Stage_p$2
XOutput_Stage_p$2_0[15|15] vout vin_pmos vin_pmos vdd vout Output_Stage_p$2
XOutput_Stage_p$2_0[0|16] vout vin_pmos vin_pmos vdd vout Output_Stage_p$2
XOutput_Stage_p$2_0[1|16] vout vin_pmos vin_pmos vdd vout Output_Stage_p$2
XOutput_Stage_p$2_0[2|16] vout vin_pmos vin_pmos vdd vout Output_Stage_p$2
XOutput_Stage_p$2_0[3|16] vout vin_pmos vin_pmos vdd vout Output_Stage_p$2
XOutput_Stage_p$2_0[4|16] vout vin_pmos vin_pmos vdd vout Output_Stage_p$2
XOutput_Stage_p$2_0[5|16] vout vin_pmos vin_pmos vdd vout Output_Stage_p$2
XOutput_Stage_p$2_0[6|16] vout vin_pmos vin_pmos vdd vout Output_Stage_p$2
XOutput_Stage_p$2_0[7|16] vout vin_pmos vin_pmos vdd vout Output_Stage_p$2
XOutput_Stage_p$2_0[8|16] vout vin_pmos vin_pmos vdd vout Output_Stage_p$2
XOutput_Stage_p$2_0[9|16] vout vin_pmos vin_pmos vdd vout Output_Stage_p$2
XOutput_Stage_p$2_0[10|16] vout vin_pmos vin_pmos vdd vout Output_Stage_p$2
XOutput_Stage_p$2_0[11|16] vout vin_pmos vin_pmos vdd vout Output_Stage_p$2
XOutput_Stage_p$2_0[12|16] vout vin_pmos vin_pmos vdd vout Output_Stage_p$2
XOutput_Stage_p$2_0[13|16] vout vin_pmos vin_pmos vdd vout Output_Stage_p$2
XOutput_Stage_p$2_0[14|16] vout vin_pmos vin_pmos vdd vout Output_Stage_p$2
XOutput_Stage_p$2_0[15|16] vout vin_pmos vin_pmos vdd vout Output_Stage_p$2
XOutput_Stage_p$2_0[0|17] vout vin_pmos vin_pmos vdd vout Output_Stage_p$2
XOutput_Stage_p$2_0[1|17] vout vin_pmos vin_pmos vdd vout Output_Stage_p$2
XOutput_Stage_p$2_0[2|17] vout vin_pmos vin_pmos vdd vout Output_Stage_p$2
XOutput_Stage_p$2_0[3|17] vout vin_pmos vin_pmos vdd vout Output_Stage_p$2
XOutput_Stage_p$2_0[4|17] vout vin_pmos vin_pmos vdd vout Output_Stage_p$2
XOutput_Stage_p$2_0[5|17] vout vin_pmos vin_pmos vdd vout Output_Stage_p$2
XOutput_Stage_p$2_0[6|17] vout vin_pmos vin_pmos vdd vout Output_Stage_p$2
XOutput_Stage_p$2_0[7|17] vout vin_pmos vin_pmos vdd vout Output_Stage_p$2
XOutput_Stage_p$2_0[8|17] vout vin_pmos vin_pmos vdd vout Output_Stage_p$2
XOutput_Stage_p$2_0[9|17] vout vin_pmos vin_pmos vdd vout Output_Stage_p$2
XOutput_Stage_p$2_0[10|17] vout vin_pmos vin_pmos vdd vout Output_Stage_p$2
XOutput_Stage_p$2_0[11|17] vout vin_pmos vin_pmos vdd vout Output_Stage_p$2
XOutput_Stage_p$2_0[12|17] vout vin_pmos vin_pmos vdd vout Output_Stage_p$2
XOutput_Stage_p$2_0[13|17] vout vin_pmos vin_pmos vdd vout Output_Stage_p$2
XOutput_Stage_p$2_0[14|17] vout vin_pmos vin_pmos vdd vout Output_Stage_p$2
XOutput_Stage_p$2_0[15|17] vout vin_pmos vin_pmos vdd vout Output_Stage_p$2
XOutput_Stage_p$2_0[0|18] vout vin_pmos vin_pmos vdd vout Output_Stage_p$2
XOutput_Stage_p$2_0[1|18] vout vin_pmos vin_pmos vdd vout Output_Stage_p$2
XOutput_Stage_p$2_0[2|18] vout vin_pmos vin_pmos vdd vout Output_Stage_p$2
XOutput_Stage_p$2_0[3|18] vout vin_pmos vin_pmos vdd vout Output_Stage_p$2
XOutput_Stage_p$2_0[4|18] vout vin_pmos vin_pmos vdd vout Output_Stage_p$2
XOutput_Stage_p$2_0[5|18] vout vin_pmos vin_pmos vdd vout Output_Stage_p$2
XOutput_Stage_p$2_0[6|18] vout vin_pmos vin_pmos vdd vout Output_Stage_p$2
XOutput_Stage_p$2_0[7|18] vout vin_pmos vin_pmos vdd vout Output_Stage_p$2
XOutput_Stage_p$2_0[8|18] vout vin_pmos vin_pmos vdd vout Output_Stage_p$2
XOutput_Stage_p$2_0[9|18] vout vin_pmos vin_pmos vdd vout Output_Stage_p$2
XOutput_Stage_p$2_0[10|18] vout vin_pmos vin_pmos vdd vout Output_Stage_p$2
XOutput_Stage_p$2_0[11|18] vout vin_pmos vin_pmos vdd vout Output_Stage_p$2
XOutput_Stage_p$2_0[12|18] vout vin_pmos vin_pmos vdd vout Output_Stage_p$2
XOutput_Stage_p$2_0[13|18] vout vin_pmos vin_pmos vdd vout Output_Stage_p$2
XOutput_Stage_p$2_0[14|18] vout vin_pmos vin_pmos vdd vout Output_Stage_p$2
XOutput_Stage_p$2_0[15|18] vout vin_pmos vin_pmos vdd vout Output_Stage_p$2
XOutput_Stage_p$2_0[0|19] vout vin_pmos vin_pmos vdd vout Output_Stage_p$2
XOutput_Stage_p$2_0[1|19] vout vin_pmos vin_pmos vdd vout Output_Stage_p$2
XOutput_Stage_p$2_0[2|19] vout vin_pmos vin_pmos vdd vout Output_Stage_p$2
XOutput_Stage_p$2_0[3|19] vout vin_pmos vin_pmos vdd vout Output_Stage_p$2
XOutput_Stage_p$2_0[4|19] vout vin_pmos vin_pmos vdd vout Output_Stage_p$2
XOutput_Stage_p$2_0[5|19] vout vin_pmos vin_pmos vdd vout Output_Stage_p$2
XOutput_Stage_p$2_0[6|19] vout vin_pmos vin_pmos vdd vout Output_Stage_p$2
XOutput_Stage_p$2_0[7|19] vout vin_pmos vin_pmos vdd vout Output_Stage_p$2
XOutput_Stage_p$2_0[8|19] vout vin_pmos vin_pmos vdd vout Output_Stage_p$2
XOutput_Stage_p$2_0[9|19] vout vin_pmos vin_pmos vdd vout Output_Stage_p$2
XOutput_Stage_p$2_0[10|19] vout vin_pmos vin_pmos vdd vout Output_Stage_p$2
XOutput_Stage_p$2_0[11|19] vout vin_pmos vin_pmos vdd vout Output_Stage_p$2
XOutput_Stage_p$2_0[12|19] vout vin_pmos vin_pmos vdd vout Output_Stage_p$2
XOutput_Stage_p$2_0[13|19] vout vin_pmos vin_pmos vdd vout Output_Stage_p$2
XOutput_Stage_p$2_0[14|19] vout vin_pmos vin_pmos vdd vout Output_Stage_p$2
XOutput_Stage_p$2_0[15|19] vout vin_pmos vin_pmos vdd vout Output_Stage_p$2
XOutput_Stage_n_0[0|0] vin_nmos vin_nmos vout vout vss Output_Stage_n
XOutput_Stage_n_0[1|0] vin_nmos vin_nmos vout vout vss Output_Stage_n
XOutput_Stage_n_0[2|0] vin_nmos vin_nmos vout vout vss Output_Stage_n
XOutput_Stage_n_0[3|0] vin_nmos vin_nmos vout vout vss Output_Stage_n
XOutput_Stage_n_0[4|0] vin_nmos vin_nmos vout vout vss Output_Stage_n
XOutput_Stage_n_0[5|0] vin_nmos vin_nmos vout vout vss Output_Stage_n
XOutput_Stage_n_0[6|0] vin_nmos vin_nmos vout vout vss Output_Stage_n
XOutput_Stage_n_0[7|0] vin_nmos vin_nmos vout vout vss Output_Stage_n
XOutput_Stage_n_0[8|0] vin_nmos vin_nmos vout vout vss Output_Stage_n
XOutput_Stage_n_0[9|0] vin_nmos vin_nmos vout vout vss Output_Stage_n
XOutput_Stage_n_0[10|0] vin_nmos vin_nmos vout vout vss Output_Stage_n
XOutput_Stage_n_0[11|0] vin_nmos vin_nmos vout vout vss Output_Stage_n
XOutput_Stage_n_0[12|0] vin_nmos vin_nmos vout vout vss Output_Stage_n
XOutput_Stage_n_0[13|0] vin_nmos vin_nmos vout vout vss Output_Stage_n
XOutput_Stage_n_0[0|1] vin_nmos vin_nmos vout vout vss Output_Stage_n
XOutput_Stage_n_0[1|1] vin_nmos vin_nmos vout vout vss Output_Stage_n
XOutput_Stage_n_0[2|1] vin_nmos vin_nmos vout vout vss Output_Stage_n
XOutput_Stage_n_0[3|1] vin_nmos vin_nmos vout vout vss Output_Stage_n
XOutput_Stage_n_0[4|1] vin_nmos vin_nmos vout vout vss Output_Stage_n
XOutput_Stage_n_0[5|1] vin_nmos vin_nmos vout vout vss Output_Stage_n
XOutput_Stage_n_0[6|1] vin_nmos vin_nmos vout vout vss Output_Stage_n
XOutput_Stage_n_0[7|1] vin_nmos vin_nmos vout vout vss Output_Stage_n
XOutput_Stage_n_0[8|1] vin_nmos vin_nmos vout vout vss Output_Stage_n
XOutput_Stage_n_0[9|1] vin_nmos vin_nmos vout vout vss Output_Stage_n
XOutput_Stage_n_0[10|1] vin_nmos vin_nmos vout vout vss Output_Stage_n
XOutput_Stage_n_0[11|1] vin_nmos vin_nmos vout vout vss Output_Stage_n
XOutput_Stage_n_0[12|1] vin_nmos vin_nmos vout vout vss Output_Stage_n
XOutput_Stage_n_0[13|1] vin_nmos vin_nmos vout vout vss Output_Stage_n
XOutput_Stage_n_0[0|2] vin_nmos vin_nmos vout vout vss Output_Stage_n
XOutput_Stage_n_0[1|2] vin_nmos vin_nmos vout vout vss Output_Stage_n
XOutput_Stage_n_0[2|2] vin_nmos vin_nmos vout vout vss Output_Stage_n
XOutput_Stage_n_0[3|2] vin_nmos vin_nmos vout vout vss Output_Stage_n
XOutput_Stage_n_0[4|2] vin_nmos vin_nmos vout vout vss Output_Stage_n
XOutput_Stage_n_0[5|2] vin_nmos vin_nmos vout vout vss Output_Stage_n
XOutput_Stage_n_0[6|2] vin_nmos vin_nmos vout vout vss Output_Stage_n
XOutput_Stage_n_0[7|2] vin_nmos vin_nmos vout vout vss Output_Stage_n
XOutput_Stage_n_0[8|2] vin_nmos vin_nmos vout vout vss Output_Stage_n
XOutput_Stage_n_0[9|2] vin_nmos vin_nmos vout vout vss Output_Stage_n
XOutput_Stage_n_0[10|2] vin_nmos vin_nmos vout vout vss Output_Stage_n
XOutput_Stage_n_0[11|2] vin_nmos vin_nmos vout vout vss Output_Stage_n
XOutput_Stage_n_0[12|2] vin_nmos vin_nmos vout vout vss Output_Stage_n
XOutput_Stage_n_0[13|2] vin_nmos vin_nmos vout vout vss Output_Stage_n
XOutput_Stage_n_0[0|3] vin_nmos vin_nmos vout vout vss Output_Stage_n
XOutput_Stage_n_0[1|3] vin_nmos vin_nmos vout vout vss Output_Stage_n
XOutput_Stage_n_0[2|3] vin_nmos vin_nmos vout vout vss Output_Stage_n
XOutput_Stage_n_0[3|3] vin_nmos vin_nmos vout vout vss Output_Stage_n
XOutput_Stage_n_0[4|3] vin_nmos vin_nmos vout vout vss Output_Stage_n
XOutput_Stage_n_0[5|3] vin_nmos vin_nmos vout vout vss Output_Stage_n
XOutput_Stage_n_0[6|3] vin_nmos vin_nmos vout vout vss Output_Stage_n
XOutput_Stage_n_0[7|3] vin_nmos vin_nmos vout vout vss Output_Stage_n
XOutput_Stage_n_0[8|3] vin_nmos vin_nmos vout vout vss Output_Stage_n
XOutput_Stage_n_0[9|3] vin_nmos vin_nmos vout vout vss Output_Stage_n
XOutput_Stage_n_0[10|3] vin_nmos vin_nmos vout vout vss Output_Stage_n
XOutput_Stage_n_0[11|3] vin_nmos vin_nmos vout vout vss Output_Stage_n
XOutput_Stage_n_0[12|3] vin_nmos vin_nmos vout vout vss Output_Stage_n
XOutput_Stage_n_0[13|3] vin_nmos vin_nmos vout vout vss Output_Stage_n
XOutput_Stage_n_0[0|4] vin_nmos vin_nmos vout vout vss Output_Stage_n
XOutput_Stage_n_0[1|4] vin_nmos vin_nmos vout vout vss Output_Stage_n
XOutput_Stage_n_0[2|4] vin_nmos vin_nmos vout vout vss Output_Stage_n
XOutput_Stage_n_0[3|4] vin_nmos vin_nmos vout vout vss Output_Stage_n
XOutput_Stage_n_0[4|4] vin_nmos vin_nmos vout vout vss Output_Stage_n
XOutput_Stage_n_0[5|4] vin_nmos vin_nmos vout vout vss Output_Stage_n
XOutput_Stage_n_0[6|4] vin_nmos vin_nmos vout vout vss Output_Stage_n
XOutput_Stage_n_0[7|4] vin_nmos vin_nmos vout vout vss Output_Stage_n
XOutput_Stage_n_0[8|4] vin_nmos vin_nmos vout vout vss Output_Stage_n
XOutput_Stage_n_0[9|4] vin_nmos vin_nmos vout vout vss Output_Stage_n
XOutput_Stage_n_0[10|4] vin_nmos vin_nmos vout vout vss Output_Stage_n
XOutput_Stage_n_0[11|4] vin_nmos vin_nmos vout vout vss Output_Stage_n
XOutput_Stage_n_0[12|4] vin_nmos vin_nmos vout vout vss Output_Stage_n
XOutput_Stage_n_0[13|4] vin_nmos vin_nmos vout vout vss Output_Stage_n
XOutput_Stage_n_0[0|5] vin_nmos vin_nmos vout vout vss Output_Stage_n
XOutput_Stage_n_0[1|5] vin_nmos vin_nmos vout vout vss Output_Stage_n
XOutput_Stage_n_0[2|5] vin_nmos vin_nmos vout vout vss Output_Stage_n
XOutput_Stage_n_0[3|5] vin_nmos vin_nmos vout vout vss Output_Stage_n
XOutput_Stage_n_0[4|5] vin_nmos vin_nmos vout vout vss Output_Stage_n
XOutput_Stage_n_0[5|5] vin_nmos vin_nmos vout vout vss Output_Stage_n
XOutput_Stage_n_0[6|5] vin_nmos vin_nmos vout vout vss Output_Stage_n
XOutput_Stage_n_0[7|5] vin_nmos vin_nmos vout vout vss Output_Stage_n
XOutput_Stage_n_0[8|5] vin_nmos vin_nmos vout vout vss Output_Stage_n
XOutput_Stage_n_0[9|5] vin_nmos vin_nmos vout vout vss Output_Stage_n
XOutput_Stage_n_0[10|5] vin_nmos vin_nmos vout vout vss Output_Stage_n
XOutput_Stage_n_0[11|5] vin_nmos vin_nmos vout vout vss Output_Stage_n
XOutput_Stage_n_0[12|5] vin_nmos vin_nmos vout vout vss Output_Stage_n
XOutput_Stage_n_0[13|5] vin_nmos vin_nmos vout vout vss Output_Stage_n
XOutput_Stage_n_0[0|6] vin_nmos vin_nmos vout vout vss Output_Stage_n
XOutput_Stage_n_0[1|6] vin_nmos vin_nmos vout vout vss Output_Stage_n
XOutput_Stage_n_0[2|6] vin_nmos vin_nmos vout vout vss Output_Stage_n
XOutput_Stage_n_0[3|6] vin_nmos vin_nmos vout vout vss Output_Stage_n
XOutput_Stage_n_0[4|6] vin_nmos vin_nmos vout vout vss Output_Stage_n
XOutput_Stage_n_0[5|6] vin_nmos vin_nmos vout vout vss Output_Stage_n
XOutput_Stage_n_0[6|6] vin_nmos vin_nmos vout vout vss Output_Stage_n
XOutput_Stage_n_0[7|6] vin_nmos vin_nmos vout vout vss Output_Stage_n
XOutput_Stage_n_0[8|6] vin_nmos vin_nmos vout vout vss Output_Stage_n
XOutput_Stage_n_0[9|6] vin_nmos vin_nmos vout vout vss Output_Stage_n
XOutput_Stage_n_0[10|6] vin_nmos vin_nmos vout vout vss Output_Stage_n
XOutput_Stage_n_0[11|6] vin_nmos vin_nmos vout vout vss Output_Stage_n
XOutput_Stage_n_0[12|6] vin_nmos vin_nmos vout vout vss Output_Stage_n
XOutput_Stage_n_0[13|6] vin_nmos vin_nmos vout vout vss Output_Stage_n
XOutput_Stage_n_0[0|7] vin_nmos vin_nmos vout vout vss Output_Stage_n
XOutput_Stage_n_0[1|7] vin_nmos vin_nmos vout vout vss Output_Stage_n
XOutput_Stage_n_0[2|7] vin_nmos vin_nmos vout vout vss Output_Stage_n
XOutput_Stage_n_0[3|7] vin_nmos vin_nmos vout vout vss Output_Stage_n
XOutput_Stage_n_0[4|7] vin_nmos vin_nmos vout vout vss Output_Stage_n
XOutput_Stage_n_0[5|7] vin_nmos vin_nmos vout vout vss Output_Stage_n
XOutput_Stage_n_0[6|7] vin_nmos vin_nmos vout vout vss Output_Stage_n
XOutput_Stage_n_0[7|7] vin_nmos vin_nmos vout vout vss Output_Stage_n
XOutput_Stage_n_0[8|7] vin_nmos vin_nmos vout vout vss Output_Stage_n
XOutput_Stage_n_0[9|7] vin_nmos vin_nmos vout vout vss Output_Stage_n
XOutput_Stage_n_0[10|7] vin_nmos vin_nmos vout vout vss Output_Stage_n
XOutput_Stage_n_0[11|7] vin_nmos vin_nmos vout vout vss Output_Stage_n
XOutput_Stage_n_0[12|7] vin_nmos vin_nmos vout vout vss Output_Stage_n
XOutput_Stage_n_0[13|7] vin_nmos vin_nmos vout vout vss Output_Stage_n
XOutput_Stage_n_0[0|8] vin_nmos vin_nmos vout vout vss Output_Stage_n
XOutput_Stage_n_0[1|8] vin_nmos vin_nmos vout vout vss Output_Stage_n
XOutput_Stage_n_0[2|8] vin_nmos vin_nmos vout vout vss Output_Stage_n
XOutput_Stage_n_0[3|8] vin_nmos vin_nmos vout vout vss Output_Stage_n
XOutput_Stage_n_0[4|8] vin_nmos vin_nmos vout vout vss Output_Stage_n
XOutput_Stage_n_0[5|8] vin_nmos vin_nmos vout vout vss Output_Stage_n
XOutput_Stage_n_0[6|8] vin_nmos vin_nmos vout vout vss Output_Stage_n
XOutput_Stage_n_0[7|8] vin_nmos vin_nmos vout vout vss Output_Stage_n
XOutput_Stage_n_0[8|8] vin_nmos vin_nmos vout vout vss Output_Stage_n
XOutput_Stage_n_0[9|8] vin_nmos vin_nmos vout vout vss Output_Stage_n
XOutput_Stage_n_0[10|8] vin_nmos vin_nmos vout vout vss Output_Stage_n
XOutput_Stage_n_0[11|8] vin_nmos vin_nmos vout vout vss Output_Stage_n
XOutput_Stage_n_0[12|8] vin_nmos vin_nmos vout vout vss Output_Stage_n
XOutput_Stage_n_0[13|8] vin_nmos vin_nmos vout vout vss Output_Stage_n
XOutput_Stage_n_0[0|9] vin_nmos vin_nmos vout vout vss Output_Stage_n
XOutput_Stage_n_0[1|9] vin_nmos vin_nmos vout vout vss Output_Stage_n
XOutput_Stage_n_0[2|9] vin_nmos vin_nmos vout vout vss Output_Stage_n
XOutput_Stage_n_0[3|9] vin_nmos vin_nmos vout vout vss Output_Stage_n
XOutput_Stage_n_0[4|9] vin_nmos vin_nmos vout vout vss Output_Stage_n
XOutput_Stage_n_0[5|9] vin_nmos vin_nmos vout vout vss Output_Stage_n
XOutput_Stage_n_0[6|9] vin_nmos vin_nmos vout vout vss Output_Stage_n
XOutput_Stage_n_0[7|9] vin_nmos vin_nmos vout vout vss Output_Stage_n
XOutput_Stage_n_0[8|9] vin_nmos vin_nmos vout vout vss Output_Stage_n
XOutput_Stage_n_0[9|9] vin_nmos vin_nmos vout vout vss Output_Stage_n
XOutput_Stage_n_0[10|9] vin_nmos vin_nmos vout vout vss Output_Stage_n
XOutput_Stage_n_0[11|9] vin_nmos vin_nmos vout vout vss Output_Stage_n
XOutput_Stage_n_0[12|9] vin_nmos vin_nmos vout vout vss Output_Stage_n
XOutput_Stage_n_0[13|9] vin_nmos vin_nmos vout vout vss Output_Stage_n
.ends
